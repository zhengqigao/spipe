     a netlist with synthetic parameters so that it is easy for debugging purpose. It worked.

    .electronic # electronic components start here until encountering .end or .photonic

    .include ./dac_model/8bit_DAC/switch.sub
    .include ./dac_model/8bit_DAC/7bit_DAC.sub

    * m1 is the output node for DAC1, will be connected to MOD1

    x1_1 vrefh net-_x1_1-pad2_ d1_0 d1_1 d1_2 d1_3 d1_4 d1_5 d1_6 vdd net-_x1_1-pad11_ s7bit_DAC
    x1_2 net-_x1_1-pad2_ vrefl d1_0 d1_1 d1_2 d1_3 d1_4 d1_5 d1_6 vdd net-_x1_2-pad11_ s7bit_DAC
    x1_3 d1_7 vdd net-_x1_1-pad11_ net-_x1_2-pad11_ m1 switch

    Vdd vdd 0 3.3
    Vd1_0 d1_0 0 PWL (0.0 0.0 9.999999960041972e-12 1.7999999523162842 1.0000000116860974e-07 1.7999999523162842 1.0000999850490189e-07 1.7999999523162842 2.0000000233721948e-07 1.7999999523162842 2.00010006778939e-07 0.0 3.000000106112566e-07 0.0 3.0000998663126666e-07 0.0 4.0000000467443897e-07 0.0 4.0001000911615847e-07 0.0 4.999999987376214e-07 0.0 5.000100031793409e-07 1.7999999523162842 6.000000212225132e-07 1.7999999523162842 6.000100256642327e-07 1.7999999523162842 6.999999868639861e-07 1.7999999523162842 7.000099913057056e-07 0.0 8.000000093488779e-07 0.0 8.000100137905974e-07 1.7999999523162842 8.999999749903509e-07 1.7999999523162842 9.000099794320704e-07 1.7999999523162842 9.999999974752427e-07 1.7999999523162842 )
    Vd1_1 d1_1 0 PWL (0.0 0.0 9.999999960041972e-12 0.0 1.0000000116860974e-07 0.0 1.0000999850490189e-07 1.7999999523162842 2.0000000233721948e-07 1.7999999523162842 2.00010006778939e-07 0.0 3.000000106112566e-07 0.0 3.0000998663126666e-07 0.0 4.0000000467443897e-07 0.0 4.0001000911615847e-07 0.0 4.999999987376214e-07 0.0 5.000100031793409e-07 1.7999999523162842 6.000000212225132e-07 1.7999999523162842 6.000100256642327e-07 1.7999999523162842 6.999999868639861e-07 1.7999999523162842 7.000099913057056e-07 0.0 8.000000093488779e-07 0.0 8.000100137905974e-07 1.7999999523162842 8.999999749903509e-07 1.7999999523162842 9.000099794320704e-07 1.7999999523162842 9.999999974752427e-07 1.7999999523162842 )
    Vd1_2 d1_2 0 PWL (0.0 0.0 9.999999960041972e-12 1.7999999523162842 1.0000000116860974e-07 1.7999999523162842 1.0000999850490189e-07 1.7999999523162842 2.0000000233721948e-07 1.7999999523162842 2.00010006778939e-07 1.7999999523162842 3.000000106112566e-07 1.7999999523162842 3.0000998663126666e-07 1.7999999523162842 4.0000000467443897e-07 1.7999999523162842 4.0001000911615847e-07 0.0 4.999999987376214e-07 0.0 5.000100031793409e-07 1.7999999523162842 6.000000212225132e-07 1.7999999523162842 6.000100256642327e-07 0.0 6.999999868639861e-07 0.0 7.000099913057056e-07 1.7999999523162842 8.000000093488779e-07 1.7999999523162842 8.000100137905974e-07 1.7999999523162842 8.999999749903509e-07 1.7999999523162842 9.000099794320704e-07 1.7999999523162842 9.999999974752427e-07 1.7999999523162842 )
    Vd1_3 d1_3 0 PWL (0.0 0.0 9.999999960041972e-12 0.0 1.0000000116860974e-07 0.0 1.0000999850490189e-07 0.0 2.0000000233721948e-07 0.0 2.00010006778939e-07 0.0 3.000000106112566e-07 0.0 3.0000998663126666e-07 0.0 4.0000000467443897e-07 0.0 4.0001000911615847e-07 1.7999999523162842 4.999999987376214e-07 1.7999999523162842 5.000100031793409e-07 1.7999999523162842 6.000000212225132e-07 1.7999999523162842 6.000100256642327e-07 1.7999999523162842 6.999999868639861e-07 1.7999999523162842 7.000099913057056e-07 0.0 8.000000093488779e-07 0.0 8.000100137905974e-07 0.0 8.999999749903509e-07 0.0 9.000099794320704e-07 1.7999999523162842 9.999999974752427e-07 1.7999999523162842 )
    Vd1_4 d1_4 0 PWL (0.0 0.0 9.999999960041972e-12 0.0 1.0000000116860974e-07 0.0 1.0000999850490189e-07 1.7999999523162842 2.0000000233721948e-07 1.7999999523162842 2.00010006778939e-07 1.7999999523162842 3.000000106112566e-07 1.7999999523162842 3.0000998663126666e-07 0.0 4.0000000467443897e-07 0.0 4.0001000911615847e-07 1.7999999523162842 4.999999987376214e-07 1.7999999523162842 5.000100031793409e-07 0.0 6.000000212225132e-07 0.0 6.000100256642327e-07 1.7999999523162842 6.999999868639861e-07 1.7999999523162842 7.000099913057056e-07 1.7999999523162842 8.000000093488779e-07 1.7999999523162842 8.000100137905974e-07 1.7999999523162842 8.999999749903509e-07 1.7999999523162842 9.000099794320704e-07 0.0 9.999999974752427e-07 0.0 )
    Vd1_5 d1_5 0 PWL (0.0 0.0 9.999999960041972e-12 0.0 1.0000000116860974e-07 0.0 1.0000999850490189e-07 0.0 2.0000000233721948e-07 0.0 2.00010006778939e-07 0.0 3.000000106112566e-07 0.0 3.0000998663126666e-07 0.0 4.0000000467443897e-07 0.0 4.0001000911615847e-07 1.7999999523162842 4.999999987376214e-07 1.7999999523162842 5.000100031793409e-07 0.0 6.000000212225132e-07 0.0 6.000100256642327e-07 0.0 6.999999868639861e-07 0.0 7.000099913057056e-07 1.7999999523162842 8.000000093488779e-07 1.7999999523162842 8.000100137905974e-07 1.7999999523162842 8.999999749903509e-07 1.7999999523162842 9.000099794320704e-07 1.7999999523162842 9.999999974752427e-07 1.7999999523162842 )
    Vd1_6 d1_6 0 PWL (0.0 0.0 9.999999960041972e-12 1.7999999523162842 1.0000000116860974e-07 1.7999999523162842 1.0000999850490189e-07 1.7999999523162842 2.0000000233721948e-07 1.7999999523162842 2.00010006778939e-07 0.0 3.000000106112566e-07 0.0 3.0000998663126666e-07 0.0 4.0000000467443897e-07 0.0 4.0001000911615847e-07 1.7999999523162842 4.999999987376214e-07 1.7999999523162842 5.000100031793409e-07 1.7999999523162842 6.000000212225132e-07 1.7999999523162842 6.000100256642327e-07 0.0 6.999999868639861e-07 0.0 7.000099913057056e-07 1.7999999523162842 8.000000093488779e-07 1.7999999523162842 8.000100137905974e-07 0.0 8.999999749903509e-07 0.0 9.000099794320704e-07 1.7999999523162842 9.999999974752427e-07 1.7999999523162842 )
    Vd1_7 d1_7 0 PWL (0.0 0.0 9.999999960041972e-12 1.7999999523162842 1.0000000116860974e-07 1.7999999523162842 1.0000999850490189e-07 1.7999999523162842 2.0000000233721948e-07 1.7999999523162842 2.00010006778939e-07 0.0 3.000000106112566e-07 0.0 3.0000998663126666e-07 1.7999999523162842 4.0000000467443897e-07 1.7999999523162842 4.0001000911615847e-07 1.7999999523162842 4.999999987376214e-07 1.7999999523162842 5.000100031793409e-07 1.7999999523162842 6.000000212225132e-07 1.7999999523162842 6.000100256642327e-07 1.7999999523162842 6.999999868639861e-07 1.7999999523162842 7.000099913057056e-07 1.7999999523162842 8.000000093488779e-07 1.7999999523162842 8.000100137905974e-07 1.7999999523162842 8.999999749903509e-07 1.7999999523162842 9.000099794320704e-07 0.0 9.999999974752427e-07 0.0 )

    * m2 is the output node for DAC2, will be connected to MOD2

    x2_1 vrefh net-_x2_1-pad2_ d2_0 d2_1 d2_2 d2_3 d2_4 d2_5 d2_6 vdd net-_x2_1-pad11_ s7bit_DAC
    x2_2 net-_x2_1-pad2_ vrefl d2_0 d2_1 d2_2 d2_3 d2_4 d2_5 d2_6 vdd net-_x2_2-pad11_ s7bit_DAC
    x2_3 d2_7 vdd net-_x2_1-pad11_ net-_x2_2-pad11_ m2 switch

    Vd2_0 d2_0 0 PWL (0.0 0.0 9.999999960041972e-12 1.7999999523162842 1.0000000116860974e-07 1.7999999523162842 1.0000999850490189e-07 0.0 2.0000000233721948e-07 0.0 2.00010006778939e-07 1.7999999523162842 3.000000106112566e-07 1.7999999523162842 3.0000998663126666e-07 0.0 4.0000000467443897e-07 0.0 4.0001000911615847e-07 0.0 4.999999987376214e-07 0.0 5.000100031793409e-07 1.7999999523162842 6.000000212225132e-07 1.7999999523162842 6.000100256642327e-07 0.0 6.999999868639861e-07 0.0 7.000099913057056e-07 0.0 8.000000093488779e-07 0.0 8.000100137905974e-07 1.7999999523162842 8.999999749903509e-07 1.7999999523162842 9.000099794320704e-07 1.7999999523162842 9.999999974752427e-07 1.7999999523162842 )
    Vd2_1 d2_1 0 PWL (0.0 0.0 9.999999960041972e-12 1.7999999523162842 1.0000000116860974e-07 1.7999999523162842 1.0000999850490189e-07 0.0 2.0000000233721948e-07 0.0 2.00010006778939e-07 1.7999999523162842 3.000000106112566e-07 1.7999999523162842 3.0000998663126666e-07 0.0 4.0000000467443897e-07 0.0 4.0001000911615847e-07 0.0 4.999999987376214e-07 0.0 5.000100031793409e-07 1.7999999523162842 6.000000212225132e-07 1.7999999523162842 6.000100256642327e-07 1.7999999523162842 6.999999868639861e-07 1.7999999523162842 7.000099913057056e-07 1.7999999523162842 8.000000093488779e-07 1.7999999523162842 8.000100137905974e-07 0.0 8.999999749903509e-07 0.0 9.000099794320704e-07 0.0 9.999999974752427e-07 0.0 )
    Vd2_2 d2_2 0 PWL (0.0 0.0 9.999999960041972e-12 1.7999999523162842 1.0000000116860974e-07 1.7999999523162842 1.0000999850490189e-07 0.0 2.0000000233721948e-07 0.0 2.00010006778939e-07 1.7999999523162842 3.000000106112566e-07 1.7999999523162842 3.0000998663126666e-07 0.0 4.0000000467443897e-07 0.0 4.0001000911615847e-07 0.0 4.999999987376214e-07 0.0 5.000100031793409e-07 0.0 6.000000212225132e-07 0.0 6.000100256642327e-07 1.7999999523162842 6.999999868639861e-07 1.7999999523162842 7.000099913057056e-07 0.0 8.000000093488779e-07 0.0 8.000100137905974e-07 1.7999999523162842 8.999999749903509e-07 1.7999999523162842 9.000099794320704e-07 0.0 9.999999974752427e-07 0.0 )
    Vd2_3 d2_3 0 PWL (0.0 0.0 9.999999960041972e-12 0.0 1.0000000116860974e-07 0.0 1.0000999850490189e-07 0.0 2.0000000233721948e-07 0.0 2.00010006778939e-07 0.0 3.000000106112566e-07 0.0 3.0000998663126666e-07 0.0 4.0000000467443897e-07 0.0 4.0001000911615847e-07 0.0 4.999999987376214e-07 0.0 5.000100031793409e-07 1.7999999523162842 6.000000212225132e-07 1.7999999523162842 6.000100256642327e-07 1.7999999523162842 6.999999868639861e-07 1.7999999523162842 7.000099913057056e-07 0.0 8.000000093488779e-07 0.0 8.000100137905974e-07 0.0 8.999999749903509e-07 0.0 9.000099794320704e-07 1.7999999523162842 9.999999974752427e-07 1.7999999523162842 )
    Vd2_4 d2_4 0 PWL (0.0 0.0 9.999999960041972e-12 0.0 1.0000000116860974e-07 0.0 1.0000999850490189e-07 1.7999999523162842 2.0000000233721948e-07 1.7999999523162842 2.00010006778939e-07 0.0 3.000000106112566e-07 0.0 3.0000998663126666e-07 1.7999999523162842 4.0000000467443897e-07 1.7999999523162842 4.0001000911615847e-07 0.0 4.999999987376214e-07 0.0 5.000100031793409e-07 0.0 6.000000212225132e-07 0.0 6.000100256642327e-07 1.7999999523162842 6.999999868639861e-07 1.7999999523162842 7.000099913057056e-07 1.7999999523162842 8.000000093488779e-07 1.7999999523162842 8.000100137905974e-07 0.0 8.999999749903509e-07 0.0 9.000099794320704e-07 0.0 9.999999974752427e-07 0.0 )
    Vd2_5 d2_5 0 PWL (0.0 0.0 9.999999960041972e-12 0.0 1.0000000116860974e-07 0.0 1.0000999850490189e-07 0.0 2.0000000233721948e-07 0.0 2.00010006778939e-07 0.0 3.000000106112566e-07 0.0 3.0000998663126666e-07 1.7999999523162842 4.0000000467443897e-07 1.7999999523162842 4.0001000911615847e-07 0.0 4.999999987376214e-07 0.0 5.000100031793409e-07 0.0 6.000000212225132e-07 0.0 6.000100256642327e-07 0.0 6.999999868639861e-07 0.0 7.000099913057056e-07 1.7999999523162842 8.000000093488779e-07 1.7999999523162842 8.000100137905974e-07 1.7999999523162842 8.999999749903509e-07 1.7999999523162842 9.000099794320704e-07 1.7999999523162842 9.999999974752427e-07 1.7999999523162842 )
    Vd2_6 d2_6 0 PWL (0.0 0.0 9.999999960041972e-12 1.7999999523162842 1.0000000116860974e-07 1.7999999523162842 1.0000999850490189e-07 0.0 2.0000000233721948e-07 0.0 2.00010006778939e-07 1.7999999523162842 3.000000106112566e-07 1.7999999523162842 3.0000998663126666e-07 0.0 4.0000000467443897e-07 0.0 4.0001000911615847e-07 0.0 4.999999987376214e-07 0.0 5.000100031793409e-07 1.7999999523162842 6.000000212225132e-07 1.7999999523162842 6.000100256642327e-07 0.0 6.999999868639861e-07 0.0 7.000099913057056e-07 0.0 8.000000093488779e-07 0.0 8.000100137905974e-07 0.0 8.999999749903509e-07 0.0 9.000099794320704e-07 0.0 9.999999974752427e-07 0.0 )
    Vd2_7 d2_7 0 PWL (0.0 0.0 9.999999960041972e-12 0.0 1.0000000116860974e-07 0.0 1.0000999850490189e-07 1.7999999523162842 2.0000000233721948e-07 1.7999999523162842 2.00010006778939e-07 0.0 3.000000106112566e-07 0.0 3.0000998663126666e-07 0.0 4.0000000467443897e-07 0.0 4.0001000911615847e-07 1.7999999523162842 4.999999987376214e-07 1.7999999523162842 5.000100031793409e-07 0.0 6.000000212225132e-07 0.0 6.000100256642327e-07 1.7999999523162842 6.999999868639861e-07 1.7999999523162842 7.000099913057056e-07 0.0 8.000000093488779e-07 0.0 8.000100137905974e-07 0.0 8.999999749903509e-07 0.0 9.000099794320704e-07 1.7999999523162842 9.999999974752427e-07 1.7999999523162842 )

    Vrefh vrefh 0 3.3
    Vrefl vrefl 0 0

    ro1 n8 0 1000.0
    ro2 n9 0 1000.0

    .options timeint reltol=1e-06 abstol=1e-06
    .print Tran v(n8) v(n9)

    .tran 0 9.999999974752427e-07 100

    .photonic # photonic components start below

    modm1 n1 n2 n3 n4 m1 debug coeff1=0.001 act_l=0.0002 alpha = 0.9
    ps1 n4 n5 ps=-0.5pi
    modm2 n3 n5 n6 n7 m2 debug coeff1=0.001 act_l=0.0002 alpha = 0.9
    pd1 n6 n8 level2 r0=0.001
    pd2 n7 n9 level2 r0=0.001

    .mode neff=2.35
    .freq 193500000000000.0 193500000000000.0 1
    .source 1.0@n1 power=0.05w eff=0.2
    .prob n6 n7

    .end
