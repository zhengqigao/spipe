.electronic
.include ./dac_model/8bit_DAC/switch.sub
.include ./dac_model/8bit_DAC/7bit_DAC.sub
Vdd vdd 0 3.3
Vrefh vrefh 0 3.3
Vrefl vrefl 0 0

    * DAC for operand fed to nac_h0_c0
x36_1 vrefh net-_x36_1-pad2_ d36_0 d36_1 d36_2 d36_3 d36_4 d36_5 d36_6 vdd net-_x36_1-pad11_ s7bit_DAC
x36_2 net-_x36_1-pad2_ vrefl d36_0 d36_1 d36_2 d36_3 d36_4 d36_5 d36_6 vdd net-_x36_2-pad11_ s7bit_DAC
x36_3 d36_7 vdd net-_x36_1-pad11_ net-_x36_2-pad11_ nac_h0_c0 switch

Vd36_0 d36_0 0 PWL (0.0 0.0 9.999999960041972e-13 1.7999999523162842 9.99999993922529e-09 1.7999999523162842 1.0001000028125873e-08 0.0 1.999999987845058e-08 0.0 2.0000999967351163e-08 1.7999999523162842 2.999999892949745e-08 1.7999999523162842 3.000100079475487e-08 0.0 3.999999975690116e-08 0.0 4.000100162215858e-08 0.0 5.000000058430487e-08 0.0 )
Vd36_1 d36_1 0 PWL (0.0 0.0 9.999999960041972e-13 1.7999999523162842 9.99999993922529e-09 1.7999999523162842 1.0001000028125873e-08 0.0 1.999999987845058e-08 0.0 2.0000999967351163e-08 1.7999999523162842 2.999999892949745e-08 1.7999999523162842 3.000100079475487e-08 0.0 3.999999975690116e-08 0.0 4.000100162215858e-08 0.0 5.000000058430487e-08 0.0 )
Vd36_2 d36_2 0 PWL (0.0 0.0 9.999999960041972e-13 1.7999999523162842 9.99999993922529e-09 1.7999999523162842 1.0001000028125873e-08 0.0 1.999999987845058e-08 0.0 2.0000999967351163e-08 1.7999999523162842 2.999999892949745e-08 1.7999999523162842 3.000100079475487e-08 0.0 3.999999975690116e-08 0.0 4.000100162215858e-08 0.0 5.000000058430487e-08 0.0 )
Vd36_3 d36_3 0 PWL (0.0 0.0 9.999999960041972e-13 0.0 9.99999993922529e-09 0.0 1.0001000028125873e-08 0.0 1.999999987845058e-08 0.0 2.0000999967351163e-08 0.0 2.999999892949745e-08 0.0 3.000100079475487e-08 0.0 3.999999975690116e-08 0.0 4.000100162215858e-08 0.0 5.000000058430487e-08 0.0 )
Vd36_4 d36_4 0 PWL (0.0 0.0 9.999999960041972e-13 0.0 9.99999993922529e-09 0.0 1.0001000028125873e-08 1.7999999523162842 1.999999987845058e-08 1.7999999523162842 2.0000999967351163e-08 0.0 2.999999892949745e-08 0.0 3.000100079475487e-08 1.7999999523162842 3.999999975690116e-08 1.7999999523162842 4.000100162215858e-08 0.0 5.000000058430487e-08 0.0 )
Vd36_5 d36_5 0 PWL (0.0 0.0 9.999999960041972e-13 0.0 9.99999993922529e-09 0.0 1.0001000028125873e-08 0.0 1.999999987845058e-08 0.0 2.0000999967351163e-08 0.0 2.999999892949745e-08 0.0 3.000100079475487e-08 1.7999999523162842 3.999999975690116e-08 1.7999999523162842 4.000100162215858e-08 0.0 5.000000058430487e-08 0.0 )
Vd36_6 d36_6 0 PWL (0.0 0.0 9.999999960041972e-13 1.7999999523162842 9.99999993922529e-09 1.7999999523162842 1.0001000028125873e-08 0.0 1.999999987845058e-08 0.0 2.0000999967351163e-08 1.7999999523162842 2.999999892949745e-08 1.7999999523162842 3.000100079475487e-08 0.0 3.999999975690116e-08 0.0 4.000100162215858e-08 0.0 5.000000058430487e-08 0.0 )
Vd36_7 d36_7 0 PWL (0.0 0.0 9.999999960041972e-13 0.0 9.99999993922529e-09 0.0 1.0001000028125873e-08 1.7999999523162842 1.999999987845058e-08 1.7999999523162842 2.0000999967351163e-08 0.0 2.999999892949745e-08 0.0 3.000100079475487e-08 0.0 3.999999975690116e-08 0.0 4.000100162215858e-08 1.7999999523162842 5.000000058430487e-08 1.7999999523162842 )

    * DAC for operand fed to nac_h1_c0
x37_1 vrefh net-_x37_1-pad2_ d37_0 d37_1 d37_2 d37_3 d37_4 d37_5 d37_6 vdd net-_x37_1-pad11_ s7bit_DAC
x37_2 net-_x37_1-pad2_ vrefl d37_0 d37_1 d37_2 d37_3 d37_4 d37_5 d37_6 vdd net-_x37_2-pad11_ s7bit_DAC
x37_3 d37_7 vdd net-_x37_1-pad11_ net-_x37_2-pad11_ nac_h1_c0 switch

Vd37_0 d37_0 0 PWL (0.0 0.0 9.999999960041972e-13 1.7999999523162842 9.99999993922529e-09 1.7999999523162842 1.0001000028125873e-08 1.7999999523162842 1.999999987845058e-08 1.7999999523162842 2.0000999967351163e-08 0.0 2.999999892949745e-08 0.0 3.000100079475487e-08 0.0 3.999999975690116e-08 0.0 4.000100162215858e-08 0.0 5.000000058430487e-08 0.0 )
Vd37_1 d37_1 0 PWL (0.0 0.0 9.999999960041972e-13 1.7999999523162842 9.99999993922529e-09 1.7999999523162842 1.0001000028125873e-08 1.7999999523162842 1.999999987845058e-08 1.7999999523162842 2.0000999967351163e-08 0.0 2.999999892949745e-08 0.0 3.000100079475487e-08 0.0 3.999999975690116e-08 0.0 4.000100162215858e-08 0.0 5.000000058430487e-08 0.0 )
Vd37_2 d37_2 0 PWL (0.0 0.0 9.999999960041972e-13 1.7999999523162842 9.99999993922529e-09 1.7999999523162842 1.0001000028125873e-08 1.7999999523162842 1.999999987845058e-08 1.7999999523162842 2.0000999967351163e-08 1.7999999523162842 2.999999892949745e-08 1.7999999523162842 3.000100079475487e-08 0.0 3.999999975690116e-08 0.0 4.000100162215858e-08 1.7999999523162842 5.000000058430487e-08 1.7999999523162842 )
Vd37_3 d37_3 0 PWL (0.0 0.0 9.999999960041972e-13 0.0 9.99999993922529e-09 0.0 1.0001000028125873e-08 1.7999999523162842 1.999999987845058e-08 1.7999999523162842 2.0000999967351163e-08 1.7999999523162842 2.999999892949745e-08 1.7999999523162842 3.000100079475487e-08 0.0 3.999999975690116e-08 0.0 4.000100162215858e-08 1.7999999523162842 5.000000058430487e-08 1.7999999523162842 )
Vd37_4 d37_4 0 PWL (0.0 0.0 9.999999960041972e-13 0.0 9.99999993922529e-09 0.0 1.0001000028125873e-08 0.0 1.999999987845058e-08 0.0 2.0000999967351163e-08 0.0 2.999999892949745e-08 0.0 3.000100079475487e-08 0.0 3.999999975690116e-08 0.0 4.000100162215858e-08 1.7999999523162842 5.000000058430487e-08 1.7999999523162842 )
Vd37_5 d37_5 0 PWL (0.0 0.0 9.999999960041972e-13 0.0 9.99999993922529e-09 0.0 1.0001000028125873e-08 1.7999999523162842 1.999999987845058e-08 1.7999999523162842 2.0000999967351163e-08 0.0 2.999999892949745e-08 0.0 3.000100079475487e-08 0.0 3.999999975690116e-08 0.0 4.000100162215858e-08 1.7999999523162842 5.000000058430487e-08 1.7999999523162842 )
Vd37_6 d37_6 0 PWL (0.0 0.0 9.999999960041972e-13 0.0 9.99999993922529e-09 0.0 1.0001000028125873e-08 0.0 1.999999987845058e-08 0.0 2.0000999967351163e-08 1.7999999523162842 2.999999892949745e-08 1.7999999523162842 3.000100079475487e-08 0.0 3.999999975690116e-08 0.0 4.000100162215858e-08 1.7999999523162842 5.000000058430487e-08 1.7999999523162842 )
Vd37_7 d37_7 0 PWL (0.0 0.0 9.999999960041972e-13 0.0 9.99999993922529e-09 0.0 1.0001000028125873e-08 0.0 1.999999987845058e-08 0.0 2.0000999967351163e-08 1.7999999523162842 2.999999892949745e-08 1.7999999523162842 3.000100079475487e-08 0.0 3.999999975690116e-08 0.0 4.000100162215858e-08 1.7999999523162842 5.000000058430487e-08 1.7999999523162842 )

    * DAC for operand fed to nac_v0_c0
x38_1 vrefh net-_x38_1-pad2_ d38_0 d38_1 d38_2 d38_3 d38_4 d38_5 d38_6 vdd net-_x38_1-pad11_ s7bit_DAC
x38_2 net-_x38_1-pad2_ vrefl d38_0 d38_1 d38_2 d38_3 d38_4 d38_5 d38_6 vdd net-_x38_2-pad11_ s7bit_DAC
x38_3 d38_7 vdd net-_x38_1-pad11_ net-_x38_2-pad11_ nac_v0_c0 switch

Vd38_0 d38_0 0 PWL (0.0 0.0 9.999999960041972e-13 0.0 9.99999993922529e-09 0.0 1.0001000028125873e-08 0.0 1.999999987845058e-08 0.0 2.0000999967351163e-08 0.0 2.999999892949745e-08 0.0 3.000100079475487e-08 1.7999999523162842 3.999999975690116e-08 1.7999999523162842 4.000100162215858e-08 1.7999999523162842 5.000000058430487e-08 1.7999999523162842 )
Vd38_1 d38_1 0 PWL (0.0 0.0 9.999999960041972e-13 0.0 9.99999993922529e-09 0.0 1.0001000028125873e-08 0.0 1.999999987845058e-08 0.0 2.0000999967351163e-08 1.7999999523162842 2.999999892949745e-08 1.7999999523162842 3.000100079475487e-08 0.0 3.999999975690116e-08 0.0 4.000100162215858e-08 1.7999999523162842 5.000000058430487e-08 1.7999999523162842 )
Vd38_2 d38_2 0 PWL (0.0 0.0 9.999999960041972e-13 0.0 9.99999993922529e-09 0.0 1.0001000028125873e-08 1.7999999523162842 1.999999987845058e-08 1.7999999523162842 2.0000999967351163e-08 0.0 2.999999892949745e-08 0.0 3.000100079475487e-08 1.7999999523162842 3.999999975690116e-08 1.7999999523162842 4.000100162215858e-08 1.7999999523162842 5.000000058430487e-08 1.7999999523162842 )
Vd38_3 d38_3 0 PWL (0.0 0.0 9.999999960041972e-13 1.7999999523162842 9.99999993922529e-09 1.7999999523162842 1.0001000028125873e-08 0.0 1.999999987845058e-08 0.0 2.0000999967351163e-08 0.0 2.999999892949745e-08 0.0 3.000100079475487e-08 0.0 3.999999975690116e-08 0.0 4.000100162215858e-08 1.7999999523162842 5.000000058430487e-08 1.7999999523162842 )
Vd38_4 d38_4 0 PWL (0.0 0.0 9.999999960041972e-13 0.0 9.99999993922529e-09 0.0 1.0001000028125873e-08 1.7999999523162842 1.999999987845058e-08 1.7999999523162842 2.0000999967351163e-08 0.0 2.999999892949745e-08 0.0 3.000100079475487e-08 0.0 3.999999975690116e-08 0.0 4.000100162215858e-08 1.7999999523162842 5.000000058430487e-08 1.7999999523162842 )
Vd38_5 d38_5 0 PWL (0.0 0.0 9.999999960041972e-13 1.7999999523162842 9.99999993922529e-09 1.7999999523162842 1.0001000028125873e-08 1.7999999523162842 1.999999987845058e-08 1.7999999523162842 2.0000999967351163e-08 1.7999999523162842 2.999999892949745e-08 1.7999999523162842 3.000100079475487e-08 0.0 3.999999975690116e-08 0.0 4.000100162215858e-08 0.0 5.000000058430487e-08 0.0 )
Vd38_6 d38_6 0 PWL (0.0 0.0 9.999999960041972e-13 1.7999999523162842 9.99999993922529e-09 1.7999999523162842 1.0001000028125873e-08 1.7999999523162842 1.999999987845058e-08 1.7999999523162842 2.0000999967351163e-08 1.7999999523162842 2.999999892949745e-08 1.7999999523162842 3.000100079475487e-08 0.0 3.999999975690116e-08 0.0 4.000100162215858e-08 0.0 5.000000058430487e-08 0.0 )
Vd38_7 d38_7 0 PWL (0.0 0.0 9.999999960041972e-13 0.0 9.99999993922529e-09 0.0 1.0001000028125873e-08 1.7999999523162842 1.999999987845058e-08 1.7999999523162842 2.0000999967351163e-08 1.7999999523162842 2.999999892949745e-08 1.7999999523162842 3.000100079475487e-08 1.7999999523162842 3.999999975690116e-08 1.7999999523162842 4.000100162215858e-08 0.0 5.000000058430487e-08 0.0 )

    * DAC for operand fed to nac_v1_c0
x39_1 vrefh net-_x39_1-pad2_ d39_0 d39_1 d39_2 d39_3 d39_4 d39_5 d39_6 vdd net-_x39_1-pad11_ s7bit_DAC
x39_2 net-_x39_1-pad2_ vrefl d39_0 d39_1 d39_2 d39_3 d39_4 d39_5 d39_6 vdd net-_x39_2-pad11_ s7bit_DAC
x39_3 d39_7 vdd net-_x39_1-pad11_ net-_x39_2-pad11_ nac_v1_c0 switch

Vd39_0 d39_0 0 PWL (0.0 0.0 9.999999960041972e-13 0.0 9.99999993922529e-09 0.0 1.0001000028125873e-08 0.0 1.999999987845058e-08 0.0 2.0000999967351163e-08 0.0 2.999999892949745e-08 0.0 3.000100079475487e-08 0.0 3.999999975690116e-08 0.0 4.000100162215858e-08 1.7999999523162842 5.000000058430487e-08 1.7999999523162842 )
Vd39_1 d39_1 0 PWL (0.0 0.0 9.999999960041972e-13 1.7999999523162842 9.99999993922529e-09 1.7999999523162842 1.0001000028125873e-08 0.0 1.999999987845058e-08 0.0 2.0000999967351163e-08 1.7999999523162842 2.999999892949745e-08 1.7999999523162842 3.000100079475487e-08 0.0 3.999999975690116e-08 0.0 4.000100162215858e-08 0.0 5.000000058430487e-08 0.0 )
Vd39_2 d39_2 0 PWL (0.0 0.0 9.999999960041972e-13 0.0 9.99999993922529e-09 0.0 1.0001000028125873e-08 1.7999999523162842 1.999999987845058e-08 1.7999999523162842 2.0000999967351163e-08 1.7999999523162842 2.999999892949745e-08 1.7999999523162842 3.000100079475487e-08 0.0 3.999999975690116e-08 0.0 4.000100162215858e-08 0.0 5.000000058430487e-08 0.0 )
Vd39_3 d39_3 0 PWL (0.0 0.0 9.999999960041972e-13 1.7999999523162842 9.99999993922529e-09 1.7999999523162842 1.0001000028125873e-08 1.7999999523162842 1.999999987845058e-08 1.7999999523162842 2.0000999967351163e-08 0.0 2.999999892949745e-08 0.0 3.000100079475487e-08 0.0 3.999999975690116e-08 0.0 4.000100162215858e-08 0.0 5.000000058430487e-08 0.0 )
Vd39_4 d39_4 0 PWL (0.0 0.0 9.999999960041972e-13 0.0 9.99999993922529e-09 0.0 1.0001000028125873e-08 1.7999999523162842 1.999999987845058e-08 1.7999999523162842 2.0000999967351163e-08 0.0 2.999999892949745e-08 0.0 3.000100079475487e-08 0.0 3.999999975690116e-08 0.0 4.000100162215858e-08 0.0 5.000000058430487e-08 0.0 )
Vd39_5 d39_5 0 PWL (0.0 0.0 9.999999960041972e-13 1.7999999523162842 9.99999993922529e-09 1.7999999523162842 1.0001000028125873e-08 1.7999999523162842 1.999999987845058e-08 1.7999999523162842 2.0000999967351163e-08 1.7999999523162842 2.999999892949745e-08 1.7999999523162842 3.000100079475487e-08 1.7999999523162842 3.999999975690116e-08 1.7999999523162842 4.000100162215858e-08 1.7999999523162842 5.000000058430487e-08 1.7999999523162842 )
Vd39_6 d39_6 0 PWL (0.0 0.0 9.999999960041972e-13 0.0 9.99999993922529e-09 0.0 1.0001000028125873e-08 1.7999999523162842 1.999999987845058e-08 1.7999999523162842 2.0000999967351163e-08 0.0 2.999999892949745e-08 0.0 3.000100079475487e-08 0.0 3.999999975690116e-08 0.0 4.000100162215858e-08 1.7999999523162842 5.000000058430487e-08 1.7999999523162842 )
Vd39_7 d39_7 0 PWL (0.0 0.0 9.999999960041972e-13 1.7999999523162842 9.99999993922529e-09 1.7999999523162842 1.0001000028125873e-08 0.0 1.999999987845058e-08 0.0 2.0000999967351163e-08 1.7999999523162842 2.999999892949745e-08 1.7999999523162842 3.000100079475487e-08 0.0 3.999999975690116e-08 0.0 4.000100162215858e-08 0.0 5.000000058430487e-08 0.0 )

    * DAC for operand fed to nac_h0_c1
x40_1 vrefh net-_x40_1-pad2_ d40_0 d40_1 d40_2 d40_3 d40_4 d40_5 d40_6 vdd net-_x40_1-pad11_ s7bit_DAC
x40_2 net-_x40_1-pad2_ vrefl d40_0 d40_1 d40_2 d40_3 d40_4 d40_5 d40_6 vdd net-_x40_2-pad11_ s7bit_DAC
x40_3 d40_7 vdd net-_x40_1-pad11_ net-_x40_2-pad11_ nac_h0_c1 switch

Vd40_0 d40_0 0 PWL (0.0 0.0 9.999999960041972e-13 1.7999999523162842 9.99999993922529e-09 1.7999999523162842 1.0001000028125873e-08 1.7999999523162842 1.999999987845058e-08 1.7999999523162842 2.0000999967351163e-08 0.0 2.999999892949745e-08 0.0 3.000100079475487e-08 0.0 3.999999975690116e-08 0.0 4.000100162215858e-08 1.7999999523162842 5.000000058430487e-08 1.7999999523162842 )
Vd40_1 d40_1 0 PWL (0.0 0.0 9.999999960041972e-13 0.0 9.99999993922529e-09 0.0 1.0001000028125873e-08 1.7999999523162842 1.999999987845058e-08 1.7999999523162842 2.0000999967351163e-08 1.7999999523162842 2.999999892949745e-08 1.7999999523162842 3.000100079475487e-08 0.0 3.999999975690116e-08 0.0 4.000100162215858e-08 1.7999999523162842 5.000000058430487e-08 1.7999999523162842 )
Vd40_2 d40_2 0 PWL (0.0 0.0 9.999999960041972e-13 1.7999999523162842 9.99999993922529e-09 1.7999999523162842 1.0001000028125873e-08 1.7999999523162842 1.999999987845058e-08 1.7999999523162842 2.0000999967351163e-08 0.0 2.999999892949745e-08 0.0 3.000100079475487e-08 0.0 3.999999975690116e-08 0.0 4.000100162215858e-08 0.0 5.000000058430487e-08 0.0 )
Vd40_3 d40_3 0 PWL (0.0 0.0 9.999999960041972e-13 0.0 9.99999993922529e-09 0.0 1.0001000028125873e-08 1.7999999523162842 1.999999987845058e-08 1.7999999523162842 2.0000999967351163e-08 1.7999999523162842 2.999999892949745e-08 1.7999999523162842 3.000100079475487e-08 1.7999999523162842 3.999999975690116e-08 1.7999999523162842 4.000100162215858e-08 0.0 5.000000058430487e-08 0.0 )
Vd40_4 d40_4 0 PWL (0.0 0.0 9.999999960041972e-13 1.7999999523162842 9.99999993922529e-09 1.7999999523162842 1.0001000028125873e-08 1.7999999523162842 1.999999987845058e-08 1.7999999523162842 2.0000999967351163e-08 0.0 2.999999892949745e-08 0.0 3.000100079475487e-08 0.0 3.999999975690116e-08 0.0 4.000100162215858e-08 1.7999999523162842 5.000000058430487e-08 1.7999999523162842 )
Vd40_5 d40_5 0 PWL (0.0 0.0 9.999999960041972e-13 0.0 9.99999993922529e-09 0.0 1.0001000028125873e-08 1.7999999523162842 1.999999987845058e-08 1.7999999523162842 2.0000999967351163e-08 1.7999999523162842 2.999999892949745e-08 1.7999999523162842 3.000100079475487e-08 1.7999999523162842 3.999999975690116e-08 1.7999999523162842 4.000100162215858e-08 0.0 5.000000058430487e-08 0.0 )
Vd40_6 d40_6 0 PWL (0.0 0.0 9.999999960041972e-13 0.0 9.99999993922529e-09 0.0 1.0001000028125873e-08 0.0 1.999999987845058e-08 0.0 2.0000999967351163e-08 0.0 2.999999892949745e-08 0.0 3.000100079475487e-08 1.7999999523162842 3.999999975690116e-08 1.7999999523162842 4.000100162215858e-08 0.0 5.000000058430487e-08 0.0 )
Vd40_7 d40_7 0 PWL (0.0 0.0 9.999999960041972e-13 1.7999999523162842 9.99999993922529e-09 1.7999999523162842 1.0001000028125873e-08 0.0 1.999999987845058e-08 0.0 2.0000999967351163e-08 1.7999999523162842 2.999999892949745e-08 1.7999999523162842 3.000100079475487e-08 0.0 3.999999975690116e-08 0.0 4.000100162215858e-08 1.7999999523162842 5.000000058430487e-08 1.7999999523162842 )

    * DAC for operand fed to nac_h1_c1
x41_1 vrefh net-_x41_1-pad2_ d41_0 d41_1 d41_2 d41_3 d41_4 d41_5 d41_6 vdd net-_x41_1-pad11_ s7bit_DAC
x41_2 net-_x41_1-pad2_ vrefl d41_0 d41_1 d41_2 d41_3 d41_4 d41_5 d41_6 vdd net-_x41_2-pad11_ s7bit_DAC
x41_3 d41_7 vdd net-_x41_1-pad11_ net-_x41_2-pad11_ nac_h1_c1 switch

Vd41_0 d41_0 0 PWL (0.0 0.0 9.999999960041972e-13 0.0 9.99999993922529e-09 0.0 1.0001000028125873e-08 1.7999999523162842 1.999999987845058e-08 1.7999999523162842 2.0000999967351163e-08 1.7999999523162842 2.999999892949745e-08 1.7999999523162842 3.000100079475487e-08 0.0 3.999999975690116e-08 0.0 4.000100162215858e-08 1.7999999523162842 5.000000058430487e-08 1.7999999523162842 )
Vd41_1 d41_1 0 PWL (0.0 0.0 9.999999960041972e-13 0.0 9.99999993922529e-09 0.0 1.0001000028125873e-08 1.7999999523162842 1.999999987845058e-08 1.7999999523162842 2.0000999967351163e-08 0.0 2.999999892949745e-08 0.0 3.000100079475487e-08 0.0 3.999999975690116e-08 0.0 4.000100162215858e-08 0.0 5.000000058430487e-08 0.0 )
Vd41_2 d41_2 0 PWL (0.0 0.0 9.999999960041972e-13 1.7999999523162842 9.99999993922529e-09 1.7999999523162842 1.0001000028125873e-08 0.0 1.999999987845058e-08 0.0 2.0000999967351163e-08 0.0 2.999999892949745e-08 0.0 3.000100079475487e-08 0.0 3.999999975690116e-08 0.0 4.000100162215858e-08 1.7999999523162842 5.000000058430487e-08 1.7999999523162842 )
Vd41_3 d41_3 0 PWL (0.0 0.0 9.999999960041972e-13 1.7999999523162842 9.99999993922529e-09 1.7999999523162842 1.0001000028125873e-08 0.0 1.999999987845058e-08 0.0 2.0000999967351163e-08 1.7999999523162842 2.999999892949745e-08 1.7999999523162842 3.000100079475487e-08 1.7999999523162842 3.999999975690116e-08 1.7999999523162842 4.000100162215858e-08 1.7999999523162842 5.000000058430487e-08 1.7999999523162842 )
Vd41_4 d41_4 0 PWL (0.0 0.0 9.999999960041972e-13 0.0 9.99999993922529e-09 0.0 1.0001000028125873e-08 1.7999999523162842 1.999999987845058e-08 1.7999999523162842 2.0000999967351163e-08 0.0 2.999999892949745e-08 0.0 3.000100079475487e-08 0.0 3.999999975690116e-08 0.0 4.000100162215858e-08 0.0 5.000000058430487e-08 0.0 )
Vd41_5 d41_5 0 PWL (0.0 0.0 9.999999960041972e-13 0.0 9.99999993922529e-09 0.0 1.0001000028125873e-08 0.0 1.999999987845058e-08 0.0 2.0000999967351163e-08 1.7999999523162842 2.999999892949745e-08 1.7999999523162842 3.000100079475487e-08 0.0 3.999999975690116e-08 0.0 4.000100162215858e-08 0.0 5.000000058430487e-08 0.0 )
Vd41_6 d41_6 0 PWL (0.0 0.0 9.999999960041972e-13 1.7999999523162842 9.99999993922529e-09 1.7999999523162842 1.0001000028125873e-08 0.0 1.999999987845058e-08 0.0 2.0000999967351163e-08 0.0 2.999999892949745e-08 0.0 3.000100079475487e-08 1.7999999523162842 3.999999975690116e-08 1.7999999523162842 4.000100162215858e-08 0.0 5.000000058430487e-08 0.0 )
Vd41_7 d41_7 0 PWL (0.0 0.0 9.999999960041972e-13 0.0 9.99999993922529e-09 0.0 1.0001000028125873e-08 0.0 1.999999987845058e-08 0.0 2.0000999967351163e-08 0.0 2.999999892949745e-08 0.0 3.000100079475487e-08 1.7999999523162842 3.999999975690116e-08 1.7999999523162842 4.000100162215858e-08 1.7999999523162842 5.000000058430487e-08 1.7999999523162842 )

    * DAC for operand fed to nac_v0_c1
x42_1 vrefh net-_x42_1-pad2_ d42_0 d42_1 d42_2 d42_3 d42_4 d42_5 d42_6 vdd net-_x42_1-pad11_ s7bit_DAC
x42_2 net-_x42_1-pad2_ vrefl d42_0 d42_1 d42_2 d42_3 d42_4 d42_5 d42_6 vdd net-_x42_2-pad11_ s7bit_DAC
x42_3 d42_7 vdd net-_x42_1-pad11_ net-_x42_2-pad11_ nac_v0_c1 switch

Vd42_0 d42_0 0 PWL (0.0 0.0 9.999999960041972e-13 1.7999999523162842 9.99999993922529e-09 1.7999999523162842 1.0001000028125873e-08 1.7999999523162842 1.999999987845058e-08 1.7999999523162842 2.0000999967351163e-08 1.7999999523162842 2.999999892949745e-08 1.7999999523162842 3.000100079475487e-08 1.7999999523162842 3.999999975690116e-08 1.7999999523162842 4.000100162215858e-08 0.0 5.000000058430487e-08 0.0 )
Vd42_1 d42_1 0 PWL (0.0 0.0 9.999999960041972e-13 0.0 9.99999993922529e-09 0.0 1.0001000028125873e-08 1.7999999523162842 1.999999987845058e-08 1.7999999523162842 2.0000999967351163e-08 1.7999999523162842 2.999999892949745e-08 1.7999999523162842 3.000100079475487e-08 0.0 3.999999975690116e-08 0.0 4.000100162215858e-08 1.7999999523162842 5.000000058430487e-08 1.7999999523162842 )
Vd42_2 d42_2 0 PWL (0.0 0.0 9.999999960041972e-13 1.7999999523162842 9.99999993922529e-09 1.7999999523162842 1.0001000028125873e-08 0.0 1.999999987845058e-08 0.0 2.0000999967351163e-08 0.0 2.999999892949745e-08 0.0 3.000100079475487e-08 1.7999999523162842 3.999999975690116e-08 1.7999999523162842 4.000100162215858e-08 0.0 5.000000058430487e-08 0.0 )
Vd42_3 d42_3 0 PWL (0.0 0.0 9.999999960041972e-13 0.0 9.99999993922529e-09 0.0 1.0001000028125873e-08 0.0 1.999999987845058e-08 0.0 2.0000999967351163e-08 0.0 2.999999892949745e-08 0.0 3.000100079475487e-08 1.7999999523162842 3.999999975690116e-08 1.7999999523162842 4.000100162215858e-08 0.0 5.000000058430487e-08 0.0 )
Vd42_4 d42_4 0 PWL (0.0 0.0 9.999999960041972e-13 0.0 9.99999993922529e-09 0.0 1.0001000028125873e-08 1.7999999523162842 1.999999987845058e-08 1.7999999523162842 2.0000999967351163e-08 0.0 2.999999892949745e-08 0.0 3.000100079475487e-08 0.0 3.999999975690116e-08 0.0 4.000100162215858e-08 0.0 5.000000058430487e-08 0.0 )
Vd42_5 d42_5 0 PWL (0.0 0.0 9.999999960041972e-13 0.0 9.99999993922529e-09 0.0 1.0001000028125873e-08 1.7999999523162842 1.999999987845058e-08 1.7999999523162842 2.0000999967351163e-08 1.7999999523162842 2.999999892949745e-08 1.7999999523162842 3.000100079475487e-08 1.7999999523162842 3.999999975690116e-08 1.7999999523162842 4.000100162215858e-08 0.0 5.000000058430487e-08 0.0 )
Vd42_6 d42_6 0 PWL (0.0 0.0 9.999999960041972e-13 0.0 9.99999993922529e-09 0.0 1.0001000028125873e-08 1.7999999523162842 1.999999987845058e-08 1.7999999523162842 2.0000999967351163e-08 0.0 2.999999892949745e-08 0.0 3.000100079475487e-08 0.0 3.999999975690116e-08 0.0 4.000100162215858e-08 1.7999999523162842 5.000000058430487e-08 1.7999999523162842 )
Vd42_7 d42_7 0 PWL (0.0 0.0 9.999999960041972e-13 1.7999999523162842 9.99999993922529e-09 1.7999999523162842 1.0001000028125873e-08 1.7999999523162842 1.999999987845058e-08 1.7999999523162842 2.0000999967351163e-08 0.0 2.999999892949745e-08 0.0 3.000100079475487e-08 0.0 3.999999975690116e-08 0.0 4.000100162215858e-08 0.0 5.000000058430487e-08 0.0 )

    * DAC for operand fed to nac_v1_c1
x43_1 vrefh net-_x43_1-pad2_ d43_0 d43_1 d43_2 d43_3 d43_4 d43_5 d43_6 vdd net-_x43_1-pad11_ s7bit_DAC
x43_2 net-_x43_1-pad2_ vrefl d43_0 d43_1 d43_2 d43_3 d43_4 d43_5 d43_6 vdd net-_x43_2-pad11_ s7bit_DAC
x43_3 d43_7 vdd net-_x43_1-pad11_ net-_x43_2-pad11_ nac_v1_c1 switch

Vd43_0 d43_0 0 PWL (0.0 0.0 9.999999960041972e-13 0.0 9.99999993922529e-09 0.0 1.0001000028125873e-08 0.0 1.999999987845058e-08 0.0 2.0000999967351163e-08 0.0 2.999999892949745e-08 0.0 3.000100079475487e-08 0.0 3.999999975690116e-08 0.0 4.000100162215858e-08 0.0 5.000000058430487e-08 0.0 )
Vd43_1 d43_1 0 PWL (0.0 0.0 9.999999960041972e-13 0.0 9.99999993922529e-09 0.0 1.0001000028125873e-08 1.7999999523162842 1.999999987845058e-08 1.7999999523162842 2.0000999967351163e-08 1.7999999523162842 2.999999892949745e-08 1.7999999523162842 3.000100079475487e-08 0.0 3.999999975690116e-08 0.0 4.000100162215858e-08 1.7999999523162842 5.000000058430487e-08 1.7999999523162842 )
Vd43_2 d43_2 0 PWL (0.0 0.0 9.999999960041972e-13 0.0 9.99999993922529e-09 0.0 1.0001000028125873e-08 1.7999999523162842 1.999999987845058e-08 1.7999999523162842 2.0000999967351163e-08 1.7999999523162842 2.999999892949745e-08 1.7999999523162842 3.000100079475487e-08 1.7999999523162842 3.999999975690116e-08 1.7999999523162842 4.000100162215858e-08 1.7999999523162842 5.000000058430487e-08 1.7999999523162842 )
Vd43_3 d43_3 0 PWL (0.0 0.0 9.999999960041972e-13 1.7999999523162842 9.99999993922529e-09 1.7999999523162842 1.0001000028125873e-08 1.7999999523162842 1.999999987845058e-08 1.7999999523162842 2.0000999967351163e-08 0.0 2.999999892949745e-08 0.0 3.000100079475487e-08 1.7999999523162842 3.999999975690116e-08 1.7999999523162842 4.000100162215858e-08 0.0 5.000000058430487e-08 0.0 )
Vd43_4 d43_4 0 PWL (0.0 0.0 9.999999960041972e-13 1.7999999523162842 9.99999993922529e-09 1.7999999523162842 1.0001000028125873e-08 0.0 1.999999987845058e-08 0.0 2.0000999967351163e-08 1.7999999523162842 2.999999892949745e-08 1.7999999523162842 3.000100079475487e-08 0.0 3.999999975690116e-08 0.0 4.000100162215858e-08 0.0 5.000000058430487e-08 0.0 )
Vd43_5 d43_5 0 PWL (0.0 0.0 9.999999960041972e-13 1.7999999523162842 9.99999993922529e-09 1.7999999523162842 1.0001000028125873e-08 1.7999999523162842 1.999999987845058e-08 1.7999999523162842 2.0000999967351163e-08 0.0 2.999999892949745e-08 0.0 3.000100079475487e-08 0.0 3.999999975690116e-08 0.0 4.000100162215858e-08 1.7999999523162842 5.000000058430487e-08 1.7999999523162842 )
Vd43_6 d43_6 0 PWL (0.0 0.0 9.999999960041972e-13 1.7999999523162842 9.99999993922529e-09 1.7999999523162842 1.0001000028125873e-08 1.7999999523162842 1.999999987845058e-08 1.7999999523162842 2.0000999967351163e-08 1.7999999523162842 2.999999892949745e-08 1.7999999523162842 3.000100079475487e-08 0.0 3.999999975690116e-08 0.0 4.000100162215858e-08 1.7999999523162842 5.000000058430487e-08 1.7999999523162842 )
Vd43_7 d43_7 0 PWL (0.0 0.0 9.999999960041972e-13 0.0 9.99999993922529e-09 0.0 1.0001000028125873e-08 0.0 1.999999987845058e-08 0.0 2.0000999967351163e-08 1.7999999523162842 2.999999892949745e-08 1.7999999523162842 3.000100079475487e-08 1.7999999523162842 3.999999975690116e-08 1.7999999523162842 4.000100162215858e-08 1.7999999523162842 5.000000058430487e-08 1.7999999523162842 )
r44 m00_up 0 10000.0
r45 m00_do 0 10000.0
r46 m01_up 0 10000.0
r47 m01_do 0 10000.0
r48 m10_up 0 10000.0
r49 m10_do 0 10000.0
r50 m11_up 0 10000.0
r51 m11_do 0 10000.0
.tran 0 5.000000058430487e-08 100
.print tran v(m00_up) v(m00_do) v(m01_up) v(m01_do) v(m10_up) v(m10_do) v(m11_up) v(m11_do)
.photonic
ps0 n00_do nd00_1 ps=-0.5pi
mzi1 n00_up nd00_1 nd00_2 nd00_3 theta=0.25pi
pd2 nd00_2 m00_up level2 r0=0.001 std=0.05
pd3 nd00_3 m00_do level2 r0=0.001 std=0.05

ps4 n01_do nd01_1 ps=-0.5pi
mzi5 n01_up nd01_1 nd01_2 nd01_3 theta=0.25pi
pd6 nd01_2 m01_up level2 r0=0.001 std=0.05
pd7 nd01_3 m01_do level2 r0=0.001 std=0.05

ps8 n10_do nd10_1 ps=-0.5pi
mzi9 n10_up nd10_1 nd10_2 nd10_3 theta=0.25pi
pd10 nd10_2 m10_up level2 r0=0.001 std=0.05
pd11 nd10_3 m10_do level2 r0=0.001 std=0.05

ps12 n11_do nd11_1 ps=-0.5pi
mzi13 n11_up nd11_1 nd11_2 nd11_3 theta=0.25pi
pd14 nd11_2 m11_up level2 r0=0.001 std=0.05
pd15 nd11_3 m11_do level2 r0=0.001 std=0.05

wdm1to2_16 h_in0 nd_h0_b_0 nd_h0_b_1
wdm1to2_17 nd_h0_bsp nd_h0_a_0 nd_h0_a_1
splitter1to2_18 nd_h0_bsp n00_up n01_up
modm19 nd_h0_b_0  nd_h0_dummy_0 nd_h0_a_0 nd_h0_dummy_1 nac_h0_c0 level1 coeff1=0.001 act_l=0.0002 alpha = 1.0
modm20 nd_h0_b_1  nd_h0_dummy_2 nd_h0_a_1 nd_h0_dummy_3 nac_h0_c1 level1 coeff1=0.001 act_l=0.0002 alpha = 1.0

wdm1to2_21 h_in1 nd_h1_b_0 nd_h1_b_1
wdm1to2_22 nd_h1_bsp nd_h1_a_0 nd_h1_a_1
splitter1to2_23 nd_h1_bsp n10_up n11_up
modm24 nd_h1_b_0  nd_h1_dummy_0 nd_h1_a_0 nd_h1_dummy_1 nac_h1_c0 level1 coeff1=0.001 act_l=0.0002 alpha = 1.0
modm25 nd_h1_b_1  nd_h1_dummy_2 nd_h1_a_1 nd_h1_dummy_3 nac_h1_c1 level1 coeff1=0.001 act_l=0.0002 alpha = 1.0

wdm1to2_26 v_in0 nd_v0_b_0 nd_v0_b_1
wdm1to2_27 nd_v0_bsp nd_v0_a_0 nd_v0_a_1
splitter1to2_28 nd_v0_bsp n00_do n10_do
modm29 nd_v0_b_0  nd_v0_dummy_0 nd_v0_a_0 nd_v0_dummy_1 nac_v0_c0 level1 coeff1=0.001 act_l=0.0002 alpha = 1.0
modm30 nd_v0_b_1  nd_v0_dummy_2 nd_v0_a_1 nd_v0_dummy_3 nac_v0_c1 level1 coeff1=0.001 act_l=0.0002 alpha = 1.0

wdm1to2_31 v_in1 nd_v1_b_0 nd_v1_b_1
wdm1to2_32 nd_v1_bsp nd_v1_a_0 nd_v1_a_1
splitter1to2_33 nd_v1_bsp n01_do n11_do
modm34 nd_v1_b_0  nd_v1_dummy_0 nd_v1_a_0 nd_v1_dummy_1 nac_v1_c0 level1 coeff1=0.001 act_l=0.0002 alpha = 1.0
modm35 nd_v1_b_1  nd_v1_dummy_2 nd_v1_a_1 nd_v1_dummy_3 nac_v1_c1 level1 coeff1=0.001 act_l=0.0002 alpha = 1.0

    .mode neff=2.35
    .freq 193500000000000.0 193500000000000.0 2
    .source 1.0@h_in0 1.0@h_in1 1.0@v_in0 1.0@v_in1 power=0.005w eff=0.2
    .prob nd_h0_bsp n00_up
    .end
