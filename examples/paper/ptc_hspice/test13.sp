.electronic
.include ./dac_model/8bit_DAC/switch.sub
.include ./dac_model/8bit_DAC/7bit_DAC.sub
Vdd vdd 0 3.3
Vrefh vrefh 0 3.3
Vrefl vrefl 0 0

    * DAC for operand fed to nac_h0_c0
x44_1 vrefh net-_x44_1-pad2_ d44_0 d44_1 d44_2 d44_3 d44_4 d44_5 d44_6 vdd net-_x44_1-pad11_ s7bit_DAC
x44_2 net-_x44_1-pad2_ vrefl d44_0 d44_1 d44_2 d44_3 d44_4 d44_5 d44_6 vdd net-_x44_2-pad11_ s7bit_DAC
x44_3 d44_7 vdd net-_x44_1-pad11_ net-_x44_2-pad11_ nac_h0_c0 switch

Vd44_0 d44_0 0 PWL (0.0 0.0 9.999999960041972e-13 1.7999999523162842 9.99999993922529e-09 1.7999999523162842 1.0001000028125873e-08 1.7999999523162842 1.999999987845058e-08 1.7999999523162842 2.0000999967351163e-08 0.0 2.999999892949745e-08 0.0 3.000100079475487e-08 0.0 3.999999975690116e-08 0.0 4.000100162215858e-08 0.0 5.000000058430487e-08 0.0 )
Vd44_1 d44_1 0 PWL (0.0 0.0 9.999999960041972e-13 0.0 9.99999993922529e-09 0.0 1.0001000028125873e-08 0.0 1.999999987845058e-08 0.0 2.0000999967351163e-08 0.0 2.999999892949745e-08 0.0 3.000100079475487e-08 1.7999999523162842 3.999999975690116e-08 1.7999999523162842 4.000100162215858e-08 0.0 5.000000058430487e-08 0.0 )
Vd44_2 d44_2 0 PWL (0.0 0.0 9.999999960041972e-13 0.0 9.99999993922529e-09 0.0 1.0001000028125873e-08 1.7999999523162842 1.999999987845058e-08 1.7999999523162842 2.0000999967351163e-08 1.7999999523162842 2.999999892949745e-08 1.7999999523162842 3.000100079475487e-08 1.7999999523162842 3.999999975690116e-08 1.7999999523162842 4.000100162215858e-08 1.7999999523162842 5.000000058430487e-08 1.7999999523162842 )
Vd44_3 d44_3 0 PWL (0.0 0.0 9.999999960041972e-13 0.0 9.99999993922529e-09 0.0 1.0001000028125873e-08 0.0 1.999999987845058e-08 0.0 2.0000999967351163e-08 1.7999999523162842 2.999999892949745e-08 1.7999999523162842 3.000100079475487e-08 1.7999999523162842 3.999999975690116e-08 1.7999999523162842 4.000100162215858e-08 0.0 5.000000058430487e-08 0.0 )
Vd44_4 d44_4 0 PWL (0.0 0.0 9.999999960041972e-13 1.7999999523162842 9.99999993922529e-09 1.7999999523162842 1.0001000028125873e-08 1.7999999523162842 1.999999987845058e-08 1.7999999523162842 2.0000999967351163e-08 1.7999999523162842 2.999999892949745e-08 1.7999999523162842 3.000100079475487e-08 0.0 3.999999975690116e-08 0.0 4.000100162215858e-08 1.7999999523162842 5.000000058430487e-08 1.7999999523162842 )
Vd44_5 d44_5 0 PWL (0.0 0.0 9.999999960041972e-13 0.0 9.99999993922529e-09 0.0 1.0001000028125873e-08 1.7999999523162842 1.999999987845058e-08 1.7999999523162842 2.0000999967351163e-08 1.7999999523162842 2.999999892949745e-08 1.7999999523162842 3.000100079475487e-08 0.0 3.999999975690116e-08 0.0 4.000100162215858e-08 0.0 5.000000058430487e-08 0.0 )
Vd44_6 d44_6 0 PWL (0.0 0.0 9.999999960041972e-13 0.0 9.99999993922529e-09 0.0 1.0001000028125873e-08 1.7999999523162842 1.999999987845058e-08 1.7999999523162842 2.0000999967351163e-08 1.7999999523162842 2.999999892949745e-08 1.7999999523162842 3.000100079475487e-08 1.7999999523162842 3.999999975690116e-08 1.7999999523162842 4.000100162215858e-08 1.7999999523162842 5.000000058430487e-08 1.7999999523162842 )
Vd44_7 d44_7 0 PWL (0.0 0.0 9.999999960041972e-13 0.0 9.99999993922529e-09 0.0 1.0001000028125873e-08 1.7999999523162842 1.999999987845058e-08 1.7999999523162842 2.0000999967351163e-08 0.0 2.999999892949745e-08 0.0 3.000100079475487e-08 1.7999999523162842 3.999999975690116e-08 1.7999999523162842 4.000100162215858e-08 1.7999999523162842 5.000000058430487e-08 1.7999999523162842 )

    * DAC for operand fed to nac_h1_c0
x45_1 vrefh net-_x45_1-pad2_ d45_0 d45_1 d45_2 d45_3 d45_4 d45_5 d45_6 vdd net-_x45_1-pad11_ s7bit_DAC
x45_2 net-_x45_1-pad2_ vrefl d45_0 d45_1 d45_2 d45_3 d45_4 d45_5 d45_6 vdd net-_x45_2-pad11_ s7bit_DAC
x45_3 d45_7 vdd net-_x45_1-pad11_ net-_x45_2-pad11_ nac_h1_c0 switch

Vd45_0 d45_0 0 PWL (0.0 0.0 9.999999960041972e-13 1.7999999523162842 9.99999993922529e-09 1.7999999523162842 1.0001000028125873e-08 0.0 1.999999987845058e-08 0.0 2.0000999967351163e-08 0.0 2.999999892949745e-08 0.0 3.000100079475487e-08 0.0 3.999999975690116e-08 0.0 4.000100162215858e-08 0.0 5.000000058430487e-08 0.0 )
Vd45_1 d45_1 0 PWL (0.0 0.0 9.999999960041972e-13 1.7999999523162842 9.99999993922529e-09 1.7999999523162842 1.0001000028125873e-08 1.7999999523162842 1.999999987845058e-08 1.7999999523162842 2.0000999967351163e-08 0.0 2.999999892949745e-08 0.0 3.000100079475487e-08 1.7999999523162842 3.999999975690116e-08 1.7999999523162842 4.000100162215858e-08 1.7999999523162842 5.000000058430487e-08 1.7999999523162842 )
Vd45_2 d45_2 0 PWL (0.0 0.0 9.999999960041972e-13 1.7999999523162842 9.99999993922529e-09 1.7999999523162842 1.0001000028125873e-08 1.7999999523162842 1.999999987845058e-08 1.7999999523162842 2.0000999967351163e-08 1.7999999523162842 2.999999892949745e-08 1.7999999523162842 3.000100079475487e-08 1.7999999523162842 3.999999975690116e-08 1.7999999523162842 4.000100162215858e-08 1.7999999523162842 5.000000058430487e-08 1.7999999523162842 )
Vd45_3 d45_3 0 PWL (0.0 0.0 9.999999960041972e-13 0.0 9.99999993922529e-09 0.0 1.0001000028125873e-08 0.0 1.999999987845058e-08 0.0 2.0000999967351163e-08 0.0 2.999999892949745e-08 0.0 3.000100079475487e-08 0.0 3.999999975690116e-08 0.0 4.000100162215858e-08 0.0 5.000000058430487e-08 0.0 )
Vd45_4 d45_4 0 PWL (0.0 0.0 9.999999960041972e-13 1.7999999523162842 9.99999993922529e-09 1.7999999523162842 1.0001000028125873e-08 1.7999999523162842 1.999999987845058e-08 1.7999999523162842 2.0000999967351163e-08 1.7999999523162842 2.999999892949745e-08 1.7999999523162842 3.000100079475487e-08 0.0 3.999999975690116e-08 0.0 4.000100162215858e-08 0.0 5.000000058430487e-08 0.0 )
Vd45_5 d45_5 0 PWL (0.0 0.0 9.999999960041972e-13 0.0 9.99999993922529e-09 0.0 1.0001000028125873e-08 0.0 1.999999987845058e-08 0.0 2.0000999967351163e-08 1.7999999523162842 2.999999892949745e-08 1.7999999523162842 3.000100079475487e-08 0.0 3.999999975690116e-08 0.0 4.000100162215858e-08 1.7999999523162842 5.000000058430487e-08 1.7999999523162842 )
Vd45_6 d45_6 0 PWL (0.0 0.0 9.999999960041972e-13 1.7999999523162842 9.99999993922529e-09 1.7999999523162842 1.0001000028125873e-08 1.7999999523162842 1.999999987845058e-08 1.7999999523162842 2.0000999967351163e-08 1.7999999523162842 2.999999892949745e-08 1.7999999523162842 3.000100079475487e-08 0.0 3.999999975690116e-08 0.0 4.000100162215858e-08 1.7999999523162842 5.000000058430487e-08 1.7999999523162842 )
Vd45_7 d45_7 0 PWL (0.0 0.0 9.999999960041972e-13 0.0 9.99999993922529e-09 0.0 1.0001000028125873e-08 0.0 1.999999987845058e-08 0.0 2.0000999967351163e-08 0.0 2.999999892949745e-08 0.0 3.000100079475487e-08 0.0 3.999999975690116e-08 0.0 4.000100162215858e-08 0.0 5.000000058430487e-08 0.0 )

    * DAC for operand fed to nac_v0_c0
x46_1 vrefh net-_x46_1-pad2_ d46_0 d46_1 d46_2 d46_3 d46_4 d46_5 d46_6 vdd net-_x46_1-pad11_ s7bit_DAC
x46_2 net-_x46_1-pad2_ vrefl d46_0 d46_1 d46_2 d46_3 d46_4 d46_5 d46_6 vdd net-_x46_2-pad11_ s7bit_DAC
x46_3 d46_7 vdd net-_x46_1-pad11_ net-_x46_2-pad11_ nac_v0_c0 switch

Vd46_0 d46_0 0 PWL (0.0 0.0 9.999999960041972e-13 1.7999999523162842 9.99999993922529e-09 1.7999999523162842 1.0001000028125873e-08 0.0 1.999999987845058e-08 0.0 2.0000999967351163e-08 0.0 2.999999892949745e-08 0.0 3.000100079475487e-08 1.7999999523162842 3.999999975690116e-08 1.7999999523162842 4.000100162215858e-08 1.7999999523162842 5.000000058430487e-08 1.7999999523162842 )
Vd46_1 d46_1 0 PWL (0.0 0.0 9.999999960041972e-13 1.7999999523162842 9.99999993922529e-09 1.7999999523162842 1.0001000028125873e-08 0.0 1.999999987845058e-08 0.0 2.0000999967351163e-08 1.7999999523162842 2.999999892949745e-08 1.7999999523162842 3.000100079475487e-08 0.0 3.999999975690116e-08 0.0 4.000100162215858e-08 0.0 5.000000058430487e-08 0.0 )
Vd46_2 d46_2 0 PWL (0.0 0.0 9.999999960041972e-13 1.7999999523162842 9.99999993922529e-09 1.7999999523162842 1.0001000028125873e-08 0.0 1.999999987845058e-08 0.0 2.0000999967351163e-08 1.7999999523162842 2.999999892949745e-08 1.7999999523162842 3.000100079475487e-08 1.7999999523162842 3.999999975690116e-08 1.7999999523162842 4.000100162215858e-08 0.0 5.000000058430487e-08 0.0 )
Vd46_3 d46_3 0 PWL (0.0 0.0 9.999999960041972e-13 1.7999999523162842 9.99999993922529e-09 1.7999999523162842 1.0001000028125873e-08 0.0 1.999999987845058e-08 0.0 2.0000999967351163e-08 0.0 2.999999892949745e-08 0.0 3.000100079475487e-08 1.7999999523162842 3.999999975690116e-08 1.7999999523162842 4.000100162215858e-08 1.7999999523162842 5.000000058430487e-08 1.7999999523162842 )
Vd46_4 d46_4 0 PWL (0.0 0.0 9.999999960041972e-13 0.0 9.99999993922529e-09 0.0 1.0001000028125873e-08 1.7999999523162842 1.999999987845058e-08 1.7999999523162842 2.0000999967351163e-08 1.7999999523162842 2.999999892949745e-08 1.7999999523162842 3.000100079475487e-08 1.7999999523162842 3.999999975690116e-08 1.7999999523162842 4.000100162215858e-08 0.0 5.000000058430487e-08 0.0 )
Vd46_5 d46_5 0 PWL (0.0 0.0 9.999999960041972e-13 0.0 9.99999993922529e-09 0.0 1.0001000028125873e-08 1.7999999523162842 1.999999987845058e-08 1.7999999523162842 2.0000999967351163e-08 0.0 2.999999892949745e-08 0.0 3.000100079475487e-08 0.0 3.999999975690116e-08 0.0 4.000100162215858e-08 0.0 5.000000058430487e-08 0.0 )
Vd46_6 d46_6 0 PWL (0.0 0.0 9.999999960041972e-13 0.0 9.99999993922529e-09 0.0 1.0001000028125873e-08 1.7999999523162842 1.999999987845058e-08 1.7999999523162842 2.0000999967351163e-08 0.0 2.999999892949745e-08 0.0 3.000100079475487e-08 0.0 3.999999975690116e-08 0.0 4.000100162215858e-08 1.7999999523162842 5.000000058430487e-08 1.7999999523162842 )
Vd46_7 d46_7 0 PWL (0.0 0.0 9.999999960041972e-13 0.0 9.99999993922529e-09 0.0 1.0001000028125873e-08 1.7999999523162842 1.999999987845058e-08 1.7999999523162842 2.0000999967351163e-08 0.0 2.999999892949745e-08 0.0 3.000100079475487e-08 1.7999999523162842 3.999999975690116e-08 1.7999999523162842 4.000100162215858e-08 1.7999999523162842 5.000000058430487e-08 1.7999999523162842 )

    * DAC for operand fed to nac_v1_c0
x47_1 vrefh net-_x47_1-pad2_ d47_0 d47_1 d47_2 d47_3 d47_4 d47_5 d47_6 vdd net-_x47_1-pad11_ s7bit_DAC
x47_2 net-_x47_1-pad2_ vrefl d47_0 d47_1 d47_2 d47_3 d47_4 d47_5 d47_6 vdd net-_x47_2-pad11_ s7bit_DAC
x47_3 d47_7 vdd net-_x47_1-pad11_ net-_x47_2-pad11_ nac_v1_c0 switch

Vd47_0 d47_0 0 PWL (0.0 0.0 9.999999960041972e-13 0.0 9.99999993922529e-09 0.0 1.0001000028125873e-08 1.7999999523162842 1.999999987845058e-08 1.7999999523162842 2.0000999967351163e-08 0.0 2.999999892949745e-08 0.0 3.000100079475487e-08 0.0 3.999999975690116e-08 0.0 4.000100162215858e-08 1.7999999523162842 5.000000058430487e-08 1.7999999523162842 )
Vd47_1 d47_1 0 PWL (0.0 0.0 9.999999960041972e-13 1.7999999523162842 9.99999993922529e-09 1.7999999523162842 1.0001000028125873e-08 1.7999999523162842 1.999999987845058e-08 1.7999999523162842 2.0000999967351163e-08 0.0 2.999999892949745e-08 0.0 3.000100079475487e-08 0.0 3.999999975690116e-08 0.0 4.000100162215858e-08 1.7999999523162842 5.000000058430487e-08 1.7999999523162842 )
Vd47_2 d47_2 0 PWL (0.0 0.0 9.999999960041972e-13 1.7999999523162842 9.99999993922529e-09 1.7999999523162842 1.0001000028125873e-08 1.7999999523162842 1.999999987845058e-08 1.7999999523162842 2.0000999967351163e-08 0.0 2.999999892949745e-08 0.0 3.000100079475487e-08 1.7999999523162842 3.999999975690116e-08 1.7999999523162842 4.000100162215858e-08 0.0 5.000000058430487e-08 0.0 )
Vd47_3 d47_3 0 PWL (0.0 0.0 9.999999960041972e-13 0.0 9.99999993922529e-09 0.0 1.0001000028125873e-08 1.7999999523162842 1.999999987845058e-08 1.7999999523162842 2.0000999967351163e-08 0.0 2.999999892949745e-08 0.0 3.000100079475487e-08 0.0 3.999999975690116e-08 0.0 4.000100162215858e-08 1.7999999523162842 5.000000058430487e-08 1.7999999523162842 )
Vd47_4 d47_4 0 PWL (0.0 0.0 9.999999960041972e-13 1.7999999523162842 9.99999993922529e-09 1.7999999523162842 1.0001000028125873e-08 0.0 1.999999987845058e-08 0.0 2.0000999967351163e-08 1.7999999523162842 2.999999892949745e-08 1.7999999523162842 3.000100079475487e-08 1.7999999523162842 3.999999975690116e-08 1.7999999523162842 4.000100162215858e-08 0.0 5.000000058430487e-08 0.0 )
Vd47_5 d47_5 0 PWL (0.0 0.0 9.999999960041972e-13 1.7999999523162842 9.99999993922529e-09 1.7999999523162842 1.0001000028125873e-08 0.0 1.999999987845058e-08 0.0 2.0000999967351163e-08 1.7999999523162842 2.999999892949745e-08 1.7999999523162842 3.000100079475487e-08 1.7999999523162842 3.999999975690116e-08 1.7999999523162842 4.000100162215858e-08 1.7999999523162842 5.000000058430487e-08 1.7999999523162842 )
Vd47_6 d47_6 0 PWL (0.0 0.0 9.999999960041972e-13 1.7999999523162842 9.99999993922529e-09 1.7999999523162842 1.0001000028125873e-08 1.7999999523162842 1.999999987845058e-08 1.7999999523162842 2.0000999967351163e-08 0.0 2.999999892949745e-08 0.0 3.000100079475487e-08 0.0 3.999999975690116e-08 0.0 4.000100162215858e-08 1.7999999523162842 5.000000058430487e-08 1.7999999523162842 )
Vd47_7 d47_7 0 PWL (0.0 0.0 9.999999960041972e-13 0.0 9.99999993922529e-09 0.0 1.0001000028125873e-08 1.7999999523162842 1.999999987845058e-08 1.7999999523162842 2.0000999967351163e-08 1.7999999523162842 2.999999892949745e-08 1.7999999523162842 3.000100079475487e-08 1.7999999523162842 3.999999975690116e-08 1.7999999523162842 4.000100162215858e-08 1.7999999523162842 5.000000058430487e-08 1.7999999523162842 )

    * DAC for operand fed to nac_h0_c1
x48_1 vrefh net-_x48_1-pad2_ d48_0 d48_1 d48_2 d48_3 d48_4 d48_5 d48_6 vdd net-_x48_1-pad11_ s7bit_DAC
x48_2 net-_x48_1-pad2_ vrefl d48_0 d48_1 d48_2 d48_3 d48_4 d48_5 d48_6 vdd net-_x48_2-pad11_ s7bit_DAC
x48_3 d48_7 vdd net-_x48_1-pad11_ net-_x48_2-pad11_ nac_h0_c1 switch

Vd48_0 d48_0 0 PWL (0.0 0.0 9.999999960041972e-13 1.7999999523162842 9.99999993922529e-09 1.7999999523162842 1.0001000028125873e-08 0.0 1.999999987845058e-08 0.0 2.0000999967351163e-08 0.0 2.999999892949745e-08 0.0 3.000100079475487e-08 0.0 3.999999975690116e-08 0.0 4.000100162215858e-08 1.7999999523162842 5.000000058430487e-08 1.7999999523162842 )
Vd48_1 d48_1 0 PWL (0.0 0.0 9.999999960041972e-13 1.7999999523162842 9.99999993922529e-09 1.7999999523162842 1.0001000028125873e-08 0.0 1.999999987845058e-08 0.0 2.0000999967351163e-08 1.7999999523162842 2.999999892949745e-08 1.7999999523162842 3.000100079475487e-08 0.0 3.999999975690116e-08 0.0 4.000100162215858e-08 0.0 5.000000058430487e-08 0.0 )
Vd48_2 d48_2 0 PWL (0.0 0.0 9.999999960041972e-13 0.0 9.99999993922529e-09 0.0 1.0001000028125873e-08 0.0 1.999999987845058e-08 0.0 2.0000999967351163e-08 1.7999999523162842 2.999999892949745e-08 1.7999999523162842 3.000100079475487e-08 1.7999999523162842 3.999999975690116e-08 1.7999999523162842 4.000100162215858e-08 0.0 5.000000058430487e-08 0.0 )
Vd48_3 d48_3 0 PWL (0.0 0.0 9.999999960041972e-13 0.0 9.99999993922529e-09 0.0 1.0001000028125873e-08 1.7999999523162842 1.999999987845058e-08 1.7999999523162842 2.0000999967351163e-08 0.0 2.999999892949745e-08 0.0 3.000100079475487e-08 0.0 3.999999975690116e-08 0.0 4.000100162215858e-08 0.0 5.000000058430487e-08 0.0 )
Vd48_4 d48_4 0 PWL (0.0 0.0 9.999999960041972e-13 1.7999999523162842 9.99999993922529e-09 1.7999999523162842 1.0001000028125873e-08 1.7999999523162842 1.999999987845058e-08 1.7999999523162842 2.0000999967351163e-08 1.7999999523162842 2.999999892949745e-08 1.7999999523162842 3.000100079475487e-08 1.7999999523162842 3.999999975690116e-08 1.7999999523162842 4.000100162215858e-08 1.7999999523162842 5.000000058430487e-08 1.7999999523162842 )
Vd48_5 d48_5 0 PWL (0.0 0.0 9.999999960041972e-13 0.0 9.99999993922529e-09 0.0 1.0001000028125873e-08 1.7999999523162842 1.999999987845058e-08 1.7999999523162842 2.0000999967351163e-08 1.7999999523162842 2.999999892949745e-08 1.7999999523162842 3.000100079475487e-08 0.0 3.999999975690116e-08 0.0 4.000100162215858e-08 1.7999999523162842 5.000000058430487e-08 1.7999999523162842 )
Vd48_6 d48_6 0 PWL (0.0 0.0 9.999999960041972e-13 1.7999999523162842 9.99999993922529e-09 1.7999999523162842 1.0001000028125873e-08 1.7999999523162842 1.999999987845058e-08 1.7999999523162842 2.0000999967351163e-08 0.0 2.999999892949745e-08 0.0 3.000100079475487e-08 1.7999999523162842 3.999999975690116e-08 1.7999999523162842 4.000100162215858e-08 0.0 5.000000058430487e-08 0.0 )
Vd48_7 d48_7 0 PWL (0.0 0.0 9.999999960041972e-13 1.7999999523162842 9.99999993922529e-09 1.7999999523162842 1.0001000028125873e-08 1.7999999523162842 1.999999987845058e-08 1.7999999523162842 2.0000999967351163e-08 1.7999999523162842 2.999999892949745e-08 1.7999999523162842 3.000100079475487e-08 1.7999999523162842 3.999999975690116e-08 1.7999999523162842 4.000100162215858e-08 1.7999999523162842 5.000000058430487e-08 1.7999999523162842 )

    * DAC for operand fed to nac_h1_c1
x49_1 vrefh net-_x49_1-pad2_ d49_0 d49_1 d49_2 d49_3 d49_4 d49_5 d49_6 vdd net-_x49_1-pad11_ s7bit_DAC
x49_2 net-_x49_1-pad2_ vrefl d49_0 d49_1 d49_2 d49_3 d49_4 d49_5 d49_6 vdd net-_x49_2-pad11_ s7bit_DAC
x49_3 d49_7 vdd net-_x49_1-pad11_ net-_x49_2-pad11_ nac_h1_c1 switch

Vd49_0 d49_0 0 PWL (0.0 0.0 9.999999960041972e-13 1.7999999523162842 9.99999993922529e-09 1.7999999523162842 1.0001000028125873e-08 1.7999999523162842 1.999999987845058e-08 1.7999999523162842 2.0000999967351163e-08 1.7999999523162842 2.999999892949745e-08 1.7999999523162842 3.000100079475487e-08 0.0 3.999999975690116e-08 0.0 4.000100162215858e-08 0.0 5.000000058430487e-08 0.0 )
Vd49_1 d49_1 0 PWL (0.0 0.0 9.999999960041972e-13 1.7999999523162842 9.99999993922529e-09 1.7999999523162842 1.0001000028125873e-08 1.7999999523162842 1.999999987845058e-08 1.7999999523162842 2.0000999967351163e-08 0.0 2.999999892949745e-08 0.0 3.000100079475487e-08 0.0 3.999999975690116e-08 0.0 4.000100162215858e-08 1.7999999523162842 5.000000058430487e-08 1.7999999523162842 )
Vd49_2 d49_2 0 PWL (0.0 0.0 9.999999960041972e-13 1.7999999523162842 9.99999993922529e-09 1.7999999523162842 1.0001000028125873e-08 1.7999999523162842 1.999999987845058e-08 1.7999999523162842 2.0000999967351163e-08 0.0 2.999999892949745e-08 0.0 3.000100079475487e-08 0.0 3.999999975690116e-08 0.0 4.000100162215858e-08 1.7999999523162842 5.000000058430487e-08 1.7999999523162842 )
Vd49_3 d49_3 0 PWL (0.0 0.0 9.999999960041972e-13 1.7999999523162842 9.99999993922529e-09 1.7999999523162842 1.0001000028125873e-08 1.7999999523162842 1.999999987845058e-08 1.7999999523162842 2.0000999967351163e-08 1.7999999523162842 2.999999892949745e-08 1.7999999523162842 3.000100079475487e-08 1.7999999523162842 3.999999975690116e-08 1.7999999523162842 4.000100162215858e-08 1.7999999523162842 5.000000058430487e-08 1.7999999523162842 )
Vd49_4 d49_4 0 PWL (0.0 0.0 9.999999960041972e-13 0.0 9.99999993922529e-09 0.0 1.0001000028125873e-08 1.7999999523162842 1.999999987845058e-08 1.7999999523162842 2.0000999967351163e-08 0.0 2.999999892949745e-08 0.0 3.000100079475487e-08 1.7999999523162842 3.999999975690116e-08 1.7999999523162842 4.000100162215858e-08 1.7999999523162842 5.000000058430487e-08 1.7999999523162842 )
Vd49_5 d49_5 0 PWL (0.0 0.0 9.999999960041972e-13 0.0 9.99999993922529e-09 0.0 1.0001000028125873e-08 1.7999999523162842 1.999999987845058e-08 1.7999999523162842 2.0000999967351163e-08 0.0 2.999999892949745e-08 0.0 3.000100079475487e-08 1.7999999523162842 3.999999975690116e-08 1.7999999523162842 4.000100162215858e-08 0.0 5.000000058430487e-08 0.0 )
Vd49_6 d49_6 0 PWL (0.0 0.0 9.999999960041972e-13 0.0 9.99999993922529e-09 0.0 1.0001000028125873e-08 1.7999999523162842 1.999999987845058e-08 1.7999999523162842 2.0000999967351163e-08 0.0 2.999999892949745e-08 0.0 3.000100079475487e-08 0.0 3.999999975690116e-08 0.0 4.000100162215858e-08 1.7999999523162842 5.000000058430487e-08 1.7999999523162842 )
Vd49_7 d49_7 0 PWL (0.0 0.0 9.999999960041972e-13 1.7999999523162842 9.99999993922529e-09 1.7999999523162842 1.0001000028125873e-08 0.0 1.999999987845058e-08 0.0 2.0000999967351163e-08 1.7999999523162842 2.999999892949745e-08 1.7999999523162842 3.000100079475487e-08 0.0 3.999999975690116e-08 0.0 4.000100162215858e-08 0.0 5.000000058430487e-08 0.0 )

    * DAC for operand fed to nac_v0_c1
x50_1 vrefh net-_x50_1-pad2_ d50_0 d50_1 d50_2 d50_3 d50_4 d50_5 d50_6 vdd net-_x50_1-pad11_ s7bit_DAC
x50_2 net-_x50_1-pad2_ vrefl d50_0 d50_1 d50_2 d50_3 d50_4 d50_5 d50_6 vdd net-_x50_2-pad11_ s7bit_DAC
x50_3 d50_7 vdd net-_x50_1-pad11_ net-_x50_2-pad11_ nac_v0_c1 switch

Vd50_0 d50_0 0 PWL (0.0 0.0 9.999999960041972e-13 0.0 9.99999993922529e-09 0.0 1.0001000028125873e-08 0.0 1.999999987845058e-08 0.0 2.0000999967351163e-08 0.0 2.999999892949745e-08 0.0 3.000100079475487e-08 1.7999999523162842 3.999999975690116e-08 1.7999999523162842 4.000100162215858e-08 1.7999999523162842 5.000000058430487e-08 1.7999999523162842 )
Vd50_1 d50_1 0 PWL (0.0 0.0 9.999999960041972e-13 0.0 9.99999993922529e-09 0.0 1.0001000028125873e-08 1.7999999523162842 1.999999987845058e-08 1.7999999523162842 2.0000999967351163e-08 0.0 2.999999892949745e-08 0.0 3.000100079475487e-08 1.7999999523162842 3.999999975690116e-08 1.7999999523162842 4.000100162215858e-08 1.7999999523162842 5.000000058430487e-08 1.7999999523162842 )
Vd50_2 d50_2 0 PWL (0.0 0.0 9.999999960041972e-13 1.7999999523162842 9.99999993922529e-09 1.7999999523162842 1.0001000028125873e-08 0.0 1.999999987845058e-08 0.0 2.0000999967351163e-08 0.0 2.999999892949745e-08 0.0 3.000100079475487e-08 1.7999999523162842 3.999999975690116e-08 1.7999999523162842 4.000100162215858e-08 1.7999999523162842 5.000000058430487e-08 1.7999999523162842 )
Vd50_3 d50_3 0 PWL (0.0 0.0 9.999999960041972e-13 0.0 9.99999993922529e-09 0.0 1.0001000028125873e-08 1.7999999523162842 1.999999987845058e-08 1.7999999523162842 2.0000999967351163e-08 1.7999999523162842 2.999999892949745e-08 1.7999999523162842 3.000100079475487e-08 0.0 3.999999975690116e-08 0.0 4.000100162215858e-08 0.0 5.000000058430487e-08 0.0 )
Vd50_4 d50_4 0 PWL (0.0 0.0 9.999999960041972e-13 0.0 9.99999993922529e-09 0.0 1.0001000028125873e-08 0.0 1.999999987845058e-08 0.0 2.0000999967351163e-08 0.0 2.999999892949745e-08 0.0 3.000100079475487e-08 0.0 3.999999975690116e-08 0.0 4.000100162215858e-08 0.0 5.000000058430487e-08 0.0 )
Vd50_5 d50_5 0 PWL (0.0 0.0 9.999999960041972e-13 1.7999999523162842 9.99999993922529e-09 1.7999999523162842 1.0001000028125873e-08 1.7999999523162842 1.999999987845058e-08 1.7999999523162842 2.0000999967351163e-08 0.0 2.999999892949745e-08 0.0 3.000100079475487e-08 1.7999999523162842 3.999999975690116e-08 1.7999999523162842 4.000100162215858e-08 0.0 5.000000058430487e-08 0.0 )
Vd50_6 d50_6 0 PWL (0.0 0.0 9.999999960041972e-13 0.0 9.99999993922529e-09 0.0 1.0001000028125873e-08 0.0 1.999999987845058e-08 0.0 2.0000999967351163e-08 0.0 2.999999892949745e-08 0.0 3.000100079475487e-08 1.7999999523162842 3.999999975690116e-08 1.7999999523162842 4.000100162215858e-08 0.0 5.000000058430487e-08 0.0 )
Vd50_7 d50_7 0 PWL (0.0 0.0 9.999999960041972e-13 0.0 9.99999993922529e-09 0.0 1.0001000028125873e-08 0.0 1.999999987845058e-08 0.0 2.0000999967351163e-08 0.0 2.999999892949745e-08 0.0 3.000100079475487e-08 1.7999999523162842 3.999999975690116e-08 1.7999999523162842 4.000100162215858e-08 0.0 5.000000058430487e-08 0.0 )

    * DAC for operand fed to nac_v1_c1
x51_1 vrefh net-_x51_1-pad2_ d51_0 d51_1 d51_2 d51_3 d51_4 d51_5 d51_6 vdd net-_x51_1-pad11_ s7bit_DAC
x51_2 net-_x51_1-pad2_ vrefl d51_0 d51_1 d51_2 d51_3 d51_4 d51_5 d51_6 vdd net-_x51_2-pad11_ s7bit_DAC
x51_3 d51_7 vdd net-_x51_1-pad11_ net-_x51_2-pad11_ nac_v1_c1 switch

Vd51_0 d51_0 0 PWL (0.0 0.0 9.999999960041972e-13 0.0 9.99999993922529e-09 0.0 1.0001000028125873e-08 0.0 1.999999987845058e-08 0.0 2.0000999967351163e-08 1.7999999523162842 2.999999892949745e-08 1.7999999523162842 3.000100079475487e-08 1.7999999523162842 3.999999975690116e-08 1.7999999523162842 4.000100162215858e-08 1.7999999523162842 5.000000058430487e-08 1.7999999523162842 )
Vd51_1 d51_1 0 PWL (0.0 0.0 9.999999960041972e-13 0.0 9.99999993922529e-09 0.0 1.0001000028125873e-08 0.0 1.999999987845058e-08 0.0 2.0000999967351163e-08 1.7999999523162842 2.999999892949745e-08 1.7999999523162842 3.000100079475487e-08 0.0 3.999999975690116e-08 0.0 4.000100162215858e-08 0.0 5.000000058430487e-08 0.0 )
Vd51_2 d51_2 0 PWL (0.0 0.0 9.999999960041972e-13 0.0 9.99999993922529e-09 0.0 1.0001000028125873e-08 1.7999999523162842 1.999999987845058e-08 1.7999999523162842 2.0000999967351163e-08 0.0 2.999999892949745e-08 0.0 3.000100079475487e-08 1.7999999523162842 3.999999975690116e-08 1.7999999523162842 4.000100162215858e-08 0.0 5.000000058430487e-08 0.0 )
Vd51_3 d51_3 0 PWL (0.0 0.0 9.999999960041972e-13 0.0 9.99999993922529e-09 0.0 1.0001000028125873e-08 0.0 1.999999987845058e-08 0.0 2.0000999967351163e-08 0.0 2.999999892949745e-08 0.0 3.000100079475487e-08 0.0 3.999999975690116e-08 0.0 4.000100162215858e-08 0.0 5.000000058430487e-08 0.0 )
Vd51_4 d51_4 0 PWL (0.0 0.0 9.999999960041972e-13 1.7999999523162842 9.99999993922529e-09 1.7999999523162842 1.0001000028125873e-08 1.7999999523162842 1.999999987845058e-08 1.7999999523162842 2.0000999967351163e-08 0.0 2.999999892949745e-08 0.0 3.000100079475487e-08 1.7999999523162842 3.999999975690116e-08 1.7999999523162842 4.000100162215858e-08 1.7999999523162842 5.000000058430487e-08 1.7999999523162842 )
Vd51_5 d51_5 0 PWL (0.0 0.0 9.999999960041972e-13 1.7999999523162842 9.99999993922529e-09 1.7999999523162842 1.0001000028125873e-08 0.0 1.999999987845058e-08 0.0 2.0000999967351163e-08 1.7999999523162842 2.999999892949745e-08 1.7999999523162842 3.000100079475487e-08 0.0 3.999999975690116e-08 0.0 4.000100162215858e-08 0.0 5.000000058430487e-08 0.0 )
Vd51_6 d51_6 0 PWL (0.0 0.0 9.999999960041972e-13 0.0 9.99999993922529e-09 0.0 1.0001000028125873e-08 0.0 1.999999987845058e-08 0.0 2.0000999967351163e-08 0.0 2.999999892949745e-08 0.0 3.000100079475487e-08 1.7999999523162842 3.999999975690116e-08 1.7999999523162842 4.000100162215858e-08 1.7999999523162842 5.000000058430487e-08 1.7999999523162842 )
Vd51_7 d51_7 0 PWL (0.0 0.0 9.999999960041972e-13 1.7999999523162842 9.99999993922529e-09 1.7999999523162842 1.0001000028125873e-08 1.7999999523162842 1.999999987845058e-08 1.7999999523162842 2.0000999967351163e-08 0.0 2.999999892949745e-08 0.0 3.000100079475487e-08 0.0 3.999999975690116e-08 0.0 4.000100162215858e-08 0.0 5.000000058430487e-08 0.0 )

    * DAC for operand fed to nac_h0_c2
x52_1 vrefh net-_x52_1-pad2_ d52_0 d52_1 d52_2 d52_3 d52_4 d52_5 d52_6 vdd net-_x52_1-pad11_ s7bit_DAC
x52_2 net-_x52_1-pad2_ vrefl d52_0 d52_1 d52_2 d52_3 d52_4 d52_5 d52_6 vdd net-_x52_2-pad11_ s7bit_DAC
x52_3 d52_7 vdd net-_x52_1-pad11_ net-_x52_2-pad11_ nac_h0_c2 switch

Vd52_0 d52_0 0 PWL (0.0 0.0 9.999999960041972e-13 1.7999999523162842 9.99999993922529e-09 1.7999999523162842 1.0001000028125873e-08 1.7999999523162842 1.999999987845058e-08 1.7999999523162842 2.0000999967351163e-08 1.7999999523162842 2.999999892949745e-08 1.7999999523162842 3.000100079475487e-08 1.7999999523162842 3.999999975690116e-08 1.7999999523162842 4.000100162215858e-08 0.0 5.000000058430487e-08 0.0 )
Vd52_1 d52_1 0 PWL (0.0 0.0 9.999999960041972e-13 1.7999999523162842 9.99999993922529e-09 1.7999999523162842 1.0001000028125873e-08 0.0 1.999999987845058e-08 0.0 2.0000999967351163e-08 1.7999999523162842 2.999999892949745e-08 1.7999999523162842 3.000100079475487e-08 1.7999999523162842 3.999999975690116e-08 1.7999999523162842 4.000100162215858e-08 0.0 5.000000058430487e-08 0.0 )
Vd52_2 d52_2 0 PWL (0.0 0.0 9.999999960041972e-13 1.7999999523162842 9.99999993922529e-09 1.7999999523162842 1.0001000028125873e-08 1.7999999523162842 1.999999987845058e-08 1.7999999523162842 2.0000999967351163e-08 1.7999999523162842 2.999999892949745e-08 1.7999999523162842 3.000100079475487e-08 1.7999999523162842 3.999999975690116e-08 1.7999999523162842 4.000100162215858e-08 0.0 5.000000058430487e-08 0.0 )
Vd52_3 d52_3 0 PWL (0.0 0.0 9.999999960041972e-13 1.7999999523162842 9.99999993922529e-09 1.7999999523162842 1.0001000028125873e-08 0.0 1.999999987845058e-08 0.0 2.0000999967351163e-08 1.7999999523162842 2.999999892949745e-08 1.7999999523162842 3.000100079475487e-08 0.0 3.999999975690116e-08 0.0 4.000100162215858e-08 0.0 5.000000058430487e-08 0.0 )
Vd52_4 d52_4 0 PWL (0.0 0.0 9.999999960041972e-13 1.7999999523162842 9.99999993922529e-09 1.7999999523162842 1.0001000028125873e-08 0.0 1.999999987845058e-08 0.0 2.0000999967351163e-08 0.0 2.999999892949745e-08 0.0 3.000100079475487e-08 1.7999999523162842 3.999999975690116e-08 1.7999999523162842 4.000100162215858e-08 0.0 5.000000058430487e-08 0.0 )
Vd52_5 d52_5 0 PWL (0.0 0.0 9.999999960041972e-13 0.0 9.99999993922529e-09 0.0 1.0001000028125873e-08 0.0 1.999999987845058e-08 0.0 2.0000999967351163e-08 1.7999999523162842 2.999999892949745e-08 1.7999999523162842 3.000100079475487e-08 0.0 3.999999975690116e-08 0.0 4.000100162215858e-08 1.7999999523162842 5.000000058430487e-08 1.7999999523162842 )
Vd52_6 d52_6 0 PWL (0.0 0.0 9.999999960041972e-13 0.0 9.99999993922529e-09 0.0 1.0001000028125873e-08 1.7999999523162842 1.999999987845058e-08 1.7999999523162842 2.0000999967351163e-08 0.0 2.999999892949745e-08 0.0 3.000100079475487e-08 1.7999999523162842 3.999999975690116e-08 1.7999999523162842 4.000100162215858e-08 1.7999999523162842 5.000000058430487e-08 1.7999999523162842 )
Vd52_7 d52_7 0 PWL (0.0 0.0 9.999999960041972e-13 1.7999999523162842 9.99999993922529e-09 1.7999999523162842 1.0001000028125873e-08 1.7999999523162842 1.999999987845058e-08 1.7999999523162842 2.0000999967351163e-08 1.7999999523162842 2.999999892949745e-08 1.7999999523162842 3.000100079475487e-08 1.7999999523162842 3.999999975690116e-08 1.7999999523162842 4.000100162215858e-08 0.0 5.000000058430487e-08 0.0 )

    * DAC for operand fed to nac_h1_c2
x53_1 vrefh net-_x53_1-pad2_ d53_0 d53_1 d53_2 d53_3 d53_4 d53_5 d53_6 vdd net-_x53_1-pad11_ s7bit_DAC
x53_2 net-_x53_1-pad2_ vrefl d53_0 d53_1 d53_2 d53_3 d53_4 d53_5 d53_6 vdd net-_x53_2-pad11_ s7bit_DAC
x53_3 d53_7 vdd net-_x53_1-pad11_ net-_x53_2-pad11_ nac_h1_c2 switch

Vd53_0 d53_0 0 PWL (0.0 0.0 9.999999960041972e-13 0.0 9.99999993922529e-09 0.0 1.0001000028125873e-08 0.0 1.999999987845058e-08 0.0 2.0000999967351163e-08 1.7999999523162842 2.999999892949745e-08 1.7999999523162842 3.000100079475487e-08 0.0 3.999999975690116e-08 0.0 4.000100162215858e-08 0.0 5.000000058430487e-08 0.0 )
Vd53_1 d53_1 0 PWL (0.0 0.0 9.999999960041972e-13 1.7999999523162842 9.99999993922529e-09 1.7999999523162842 1.0001000028125873e-08 1.7999999523162842 1.999999987845058e-08 1.7999999523162842 2.0000999967351163e-08 1.7999999523162842 2.999999892949745e-08 1.7999999523162842 3.000100079475487e-08 1.7999999523162842 3.999999975690116e-08 1.7999999523162842 4.000100162215858e-08 0.0 5.000000058430487e-08 0.0 )
Vd53_2 d53_2 0 PWL (0.0 0.0 9.999999960041972e-13 1.7999999523162842 9.99999993922529e-09 1.7999999523162842 1.0001000028125873e-08 0.0 1.999999987845058e-08 0.0 2.0000999967351163e-08 1.7999999523162842 2.999999892949745e-08 1.7999999523162842 3.000100079475487e-08 0.0 3.999999975690116e-08 0.0 4.000100162215858e-08 1.7999999523162842 5.000000058430487e-08 1.7999999523162842 )
Vd53_3 d53_3 0 PWL (0.0 0.0 9.999999960041972e-13 0.0 9.99999993922529e-09 0.0 1.0001000028125873e-08 0.0 1.999999987845058e-08 0.0 2.0000999967351163e-08 1.7999999523162842 2.999999892949745e-08 1.7999999523162842 3.000100079475487e-08 1.7999999523162842 3.999999975690116e-08 1.7999999523162842 4.000100162215858e-08 0.0 5.000000058430487e-08 0.0 )
Vd53_4 d53_4 0 PWL (0.0 0.0 9.999999960041972e-13 0.0 9.99999993922529e-09 0.0 1.0001000028125873e-08 1.7999999523162842 1.999999987845058e-08 1.7999999523162842 2.0000999967351163e-08 0.0 2.999999892949745e-08 0.0 3.000100079475487e-08 0.0 3.999999975690116e-08 0.0 4.000100162215858e-08 0.0 5.000000058430487e-08 0.0 )
Vd53_5 d53_5 0 PWL (0.0 0.0 9.999999960041972e-13 1.7999999523162842 9.99999993922529e-09 1.7999999523162842 1.0001000028125873e-08 1.7999999523162842 1.999999987845058e-08 1.7999999523162842 2.0000999967351163e-08 0.0 2.999999892949745e-08 0.0 3.000100079475487e-08 0.0 3.999999975690116e-08 0.0 4.000100162215858e-08 1.7999999523162842 5.000000058430487e-08 1.7999999523162842 )
Vd53_6 d53_6 0 PWL (0.0 0.0 9.999999960041972e-13 1.7999999523162842 9.99999993922529e-09 1.7999999523162842 1.0001000028125873e-08 1.7999999523162842 1.999999987845058e-08 1.7999999523162842 2.0000999967351163e-08 0.0 2.999999892949745e-08 0.0 3.000100079475487e-08 1.7999999523162842 3.999999975690116e-08 1.7999999523162842 4.000100162215858e-08 0.0 5.000000058430487e-08 0.0 )
Vd53_7 d53_7 0 PWL (0.0 0.0 9.999999960041972e-13 1.7999999523162842 9.99999993922529e-09 1.7999999523162842 1.0001000028125873e-08 0.0 1.999999987845058e-08 0.0 2.0000999967351163e-08 0.0 2.999999892949745e-08 0.0 3.000100079475487e-08 1.7999999523162842 3.999999975690116e-08 1.7999999523162842 4.000100162215858e-08 1.7999999523162842 5.000000058430487e-08 1.7999999523162842 )

    * DAC for operand fed to nac_v0_c2
x54_1 vrefh net-_x54_1-pad2_ d54_0 d54_1 d54_2 d54_3 d54_4 d54_5 d54_6 vdd net-_x54_1-pad11_ s7bit_DAC
x54_2 net-_x54_1-pad2_ vrefl d54_0 d54_1 d54_2 d54_3 d54_4 d54_5 d54_6 vdd net-_x54_2-pad11_ s7bit_DAC
x54_3 d54_7 vdd net-_x54_1-pad11_ net-_x54_2-pad11_ nac_v0_c2 switch

Vd54_0 d54_0 0 PWL (0.0 0.0 9.999999960041972e-13 0.0 9.99999993922529e-09 0.0 1.0001000028125873e-08 0.0 1.999999987845058e-08 0.0 2.0000999967351163e-08 0.0 2.999999892949745e-08 0.0 3.000100079475487e-08 0.0 3.999999975690116e-08 0.0 4.000100162215858e-08 0.0 5.000000058430487e-08 0.0 )
Vd54_1 d54_1 0 PWL (0.0 0.0 9.999999960041972e-13 1.7999999523162842 9.99999993922529e-09 1.7999999523162842 1.0001000028125873e-08 1.7999999523162842 1.999999987845058e-08 1.7999999523162842 2.0000999967351163e-08 0.0 2.999999892949745e-08 0.0 3.000100079475487e-08 1.7999999523162842 3.999999975690116e-08 1.7999999523162842 4.000100162215858e-08 0.0 5.000000058430487e-08 0.0 )
Vd54_2 d54_2 0 PWL (0.0 0.0 9.999999960041972e-13 0.0 9.99999993922529e-09 0.0 1.0001000028125873e-08 0.0 1.999999987845058e-08 0.0 2.0000999967351163e-08 1.7999999523162842 2.999999892949745e-08 1.7999999523162842 3.000100079475487e-08 0.0 3.999999975690116e-08 0.0 4.000100162215858e-08 0.0 5.000000058430487e-08 0.0 )
Vd54_3 d54_3 0 PWL (0.0 0.0 9.999999960041972e-13 0.0 9.99999993922529e-09 0.0 1.0001000028125873e-08 0.0 1.999999987845058e-08 0.0 2.0000999967351163e-08 0.0 2.999999892949745e-08 0.0 3.000100079475487e-08 1.7999999523162842 3.999999975690116e-08 1.7999999523162842 4.000100162215858e-08 0.0 5.000000058430487e-08 0.0 )
Vd54_4 d54_4 0 PWL (0.0 0.0 9.999999960041972e-13 1.7999999523162842 9.99999993922529e-09 1.7999999523162842 1.0001000028125873e-08 1.7999999523162842 1.999999987845058e-08 1.7999999523162842 2.0000999967351163e-08 0.0 2.999999892949745e-08 0.0 3.000100079475487e-08 1.7999999523162842 3.999999975690116e-08 1.7999999523162842 4.000100162215858e-08 1.7999999523162842 5.000000058430487e-08 1.7999999523162842 )
Vd54_5 d54_5 0 PWL (0.0 0.0 9.999999960041972e-13 0.0 9.99999993922529e-09 0.0 1.0001000028125873e-08 0.0 1.999999987845058e-08 0.0 2.0000999967351163e-08 1.7999999523162842 2.999999892949745e-08 1.7999999523162842 3.000100079475487e-08 0.0 3.999999975690116e-08 0.0 4.000100162215858e-08 1.7999999523162842 5.000000058430487e-08 1.7999999523162842 )
Vd54_6 d54_6 0 PWL (0.0 0.0 9.999999960041972e-13 0.0 9.99999993922529e-09 0.0 1.0001000028125873e-08 1.7999999523162842 1.999999987845058e-08 1.7999999523162842 2.0000999967351163e-08 1.7999999523162842 2.999999892949745e-08 1.7999999523162842 3.000100079475487e-08 1.7999999523162842 3.999999975690116e-08 1.7999999523162842 4.000100162215858e-08 1.7999999523162842 5.000000058430487e-08 1.7999999523162842 )
Vd54_7 d54_7 0 PWL (0.0 0.0 9.999999960041972e-13 0.0 9.99999993922529e-09 0.0 1.0001000028125873e-08 0.0 1.999999987845058e-08 0.0 2.0000999967351163e-08 1.7999999523162842 2.999999892949745e-08 1.7999999523162842 3.000100079475487e-08 1.7999999523162842 3.999999975690116e-08 1.7999999523162842 4.000100162215858e-08 0.0 5.000000058430487e-08 0.0 )

    * DAC for operand fed to nac_v1_c2
x55_1 vrefh net-_x55_1-pad2_ d55_0 d55_1 d55_2 d55_3 d55_4 d55_5 d55_6 vdd net-_x55_1-pad11_ s7bit_DAC
x55_2 net-_x55_1-pad2_ vrefl d55_0 d55_1 d55_2 d55_3 d55_4 d55_5 d55_6 vdd net-_x55_2-pad11_ s7bit_DAC
x55_3 d55_7 vdd net-_x55_1-pad11_ net-_x55_2-pad11_ nac_v1_c2 switch

Vd55_0 d55_0 0 PWL (0.0 0.0 9.999999960041972e-13 0.0 9.99999993922529e-09 0.0 1.0001000028125873e-08 0.0 1.999999987845058e-08 0.0 2.0000999967351163e-08 0.0 2.999999892949745e-08 0.0 3.000100079475487e-08 0.0 3.999999975690116e-08 0.0 4.000100162215858e-08 0.0 5.000000058430487e-08 0.0 )
Vd55_1 d55_1 0 PWL (0.0 0.0 9.999999960041972e-13 1.7999999523162842 9.99999993922529e-09 1.7999999523162842 1.0001000028125873e-08 1.7999999523162842 1.999999987845058e-08 1.7999999523162842 2.0000999967351163e-08 0.0 2.999999892949745e-08 0.0 3.000100079475487e-08 0.0 3.999999975690116e-08 0.0 4.000100162215858e-08 0.0 5.000000058430487e-08 0.0 )
Vd55_2 d55_2 0 PWL (0.0 0.0 9.999999960041972e-13 0.0 9.99999993922529e-09 0.0 1.0001000028125873e-08 1.7999999523162842 1.999999987845058e-08 1.7999999523162842 2.0000999967351163e-08 0.0 2.999999892949745e-08 0.0 3.000100079475487e-08 0.0 3.999999975690116e-08 0.0 4.000100162215858e-08 1.7999999523162842 5.000000058430487e-08 1.7999999523162842 )
Vd55_3 d55_3 0 PWL (0.0 0.0 9.999999960041972e-13 1.7999999523162842 9.99999993922529e-09 1.7999999523162842 1.0001000028125873e-08 1.7999999523162842 1.999999987845058e-08 1.7999999523162842 2.0000999967351163e-08 1.7999999523162842 2.999999892949745e-08 1.7999999523162842 3.000100079475487e-08 0.0 3.999999975690116e-08 0.0 4.000100162215858e-08 1.7999999523162842 5.000000058430487e-08 1.7999999523162842 )
Vd55_4 d55_4 0 PWL (0.0 0.0 9.999999960041972e-13 1.7999999523162842 9.99999993922529e-09 1.7999999523162842 1.0001000028125873e-08 1.7999999523162842 1.999999987845058e-08 1.7999999523162842 2.0000999967351163e-08 1.7999999523162842 2.999999892949745e-08 1.7999999523162842 3.000100079475487e-08 0.0 3.999999975690116e-08 0.0 4.000100162215858e-08 0.0 5.000000058430487e-08 0.0 )
Vd55_5 d55_5 0 PWL (0.0 0.0 9.999999960041972e-13 0.0 9.99999993922529e-09 0.0 1.0001000028125873e-08 0.0 1.999999987845058e-08 0.0 2.0000999967351163e-08 0.0 2.999999892949745e-08 0.0 3.000100079475487e-08 0.0 3.999999975690116e-08 0.0 4.000100162215858e-08 1.7999999523162842 5.000000058430487e-08 1.7999999523162842 )
Vd55_6 d55_6 0 PWL (0.0 0.0 9.999999960041972e-13 1.7999999523162842 9.99999993922529e-09 1.7999999523162842 1.0001000028125873e-08 0.0 1.999999987845058e-08 0.0 2.0000999967351163e-08 0.0 2.999999892949745e-08 0.0 3.000100079475487e-08 1.7999999523162842 3.999999975690116e-08 1.7999999523162842 4.000100162215858e-08 1.7999999523162842 5.000000058430487e-08 1.7999999523162842 )
Vd55_7 d55_7 0 PWL (0.0 0.0 9.999999960041972e-13 1.7999999523162842 9.99999993922529e-09 1.7999999523162842 1.0001000028125873e-08 0.0 1.999999987845058e-08 0.0 2.0000999967351163e-08 1.7999999523162842 2.999999892949745e-08 1.7999999523162842 3.000100079475487e-08 0.0 3.999999975690116e-08 0.0 4.000100162215858e-08 0.0 5.000000058430487e-08 0.0 )

    * DAC for operand fed to nac_h0_c3
x56_1 vrefh net-_x56_1-pad2_ d56_0 d56_1 d56_2 d56_3 d56_4 d56_5 d56_6 vdd net-_x56_1-pad11_ s7bit_DAC
x56_2 net-_x56_1-pad2_ vrefl d56_0 d56_1 d56_2 d56_3 d56_4 d56_5 d56_6 vdd net-_x56_2-pad11_ s7bit_DAC
x56_3 d56_7 vdd net-_x56_1-pad11_ net-_x56_2-pad11_ nac_h0_c3 switch

Vd56_0 d56_0 0 PWL (0.0 0.0 9.999999960041972e-13 0.0 9.99999993922529e-09 0.0 1.0001000028125873e-08 1.7999999523162842 1.999999987845058e-08 1.7999999523162842 2.0000999967351163e-08 1.7999999523162842 2.999999892949745e-08 1.7999999523162842 3.000100079475487e-08 1.7999999523162842 3.999999975690116e-08 1.7999999523162842 4.000100162215858e-08 1.7999999523162842 5.000000058430487e-08 1.7999999523162842 )
Vd56_1 d56_1 0 PWL (0.0 0.0 9.999999960041972e-13 0.0 9.99999993922529e-09 0.0 1.0001000028125873e-08 1.7999999523162842 1.999999987845058e-08 1.7999999523162842 2.0000999967351163e-08 1.7999999523162842 2.999999892949745e-08 1.7999999523162842 3.000100079475487e-08 1.7999999523162842 3.999999975690116e-08 1.7999999523162842 4.000100162215858e-08 1.7999999523162842 5.000000058430487e-08 1.7999999523162842 )
Vd56_2 d56_2 0 PWL (0.0 0.0 9.999999960041972e-13 1.7999999523162842 9.99999993922529e-09 1.7999999523162842 1.0001000028125873e-08 0.0 1.999999987845058e-08 0.0 2.0000999967351163e-08 1.7999999523162842 2.999999892949745e-08 1.7999999523162842 3.000100079475487e-08 0.0 3.999999975690116e-08 0.0 4.000100162215858e-08 1.7999999523162842 5.000000058430487e-08 1.7999999523162842 )
Vd56_3 d56_3 0 PWL (0.0 0.0 9.999999960041972e-13 0.0 9.99999993922529e-09 0.0 1.0001000028125873e-08 0.0 1.999999987845058e-08 0.0 2.0000999967351163e-08 1.7999999523162842 2.999999892949745e-08 1.7999999523162842 3.000100079475487e-08 1.7999999523162842 3.999999975690116e-08 1.7999999523162842 4.000100162215858e-08 0.0 5.000000058430487e-08 0.0 )
Vd56_4 d56_4 0 PWL (0.0 0.0 9.999999960041972e-13 0.0 9.99999993922529e-09 0.0 1.0001000028125873e-08 1.7999999523162842 1.999999987845058e-08 1.7999999523162842 2.0000999967351163e-08 0.0 2.999999892949745e-08 0.0 3.000100079475487e-08 0.0 3.999999975690116e-08 0.0 4.000100162215858e-08 1.7999999523162842 5.000000058430487e-08 1.7999999523162842 )
Vd56_5 d56_5 0 PWL (0.0 0.0 9.999999960041972e-13 0.0 9.99999993922529e-09 0.0 1.0001000028125873e-08 0.0 1.999999987845058e-08 0.0 2.0000999967351163e-08 1.7999999523162842 2.999999892949745e-08 1.7999999523162842 3.000100079475487e-08 1.7999999523162842 3.999999975690116e-08 1.7999999523162842 4.000100162215858e-08 0.0 5.000000058430487e-08 0.0 )
Vd56_6 d56_6 0 PWL (0.0 0.0 9.999999960041972e-13 0.0 9.99999993922529e-09 0.0 1.0001000028125873e-08 0.0 1.999999987845058e-08 0.0 2.0000999967351163e-08 1.7999999523162842 2.999999892949745e-08 1.7999999523162842 3.000100079475487e-08 1.7999999523162842 3.999999975690116e-08 1.7999999523162842 4.000100162215858e-08 1.7999999523162842 5.000000058430487e-08 1.7999999523162842 )
Vd56_7 d56_7 0 PWL (0.0 0.0 9.999999960041972e-13 0.0 9.99999993922529e-09 0.0 1.0001000028125873e-08 0.0 1.999999987845058e-08 0.0 2.0000999967351163e-08 0.0 2.999999892949745e-08 0.0 3.000100079475487e-08 1.7999999523162842 3.999999975690116e-08 1.7999999523162842 4.000100162215858e-08 0.0 5.000000058430487e-08 0.0 )

    * DAC for operand fed to nac_h1_c3
x57_1 vrefh net-_x57_1-pad2_ d57_0 d57_1 d57_2 d57_3 d57_4 d57_5 d57_6 vdd net-_x57_1-pad11_ s7bit_DAC
x57_2 net-_x57_1-pad2_ vrefl d57_0 d57_1 d57_2 d57_3 d57_4 d57_5 d57_6 vdd net-_x57_2-pad11_ s7bit_DAC
x57_3 d57_7 vdd net-_x57_1-pad11_ net-_x57_2-pad11_ nac_h1_c3 switch

Vd57_0 d57_0 0 PWL (0.0 0.0 9.999999960041972e-13 1.7999999523162842 9.99999993922529e-09 1.7999999523162842 1.0001000028125873e-08 0.0 1.999999987845058e-08 0.0 2.0000999967351163e-08 1.7999999523162842 2.999999892949745e-08 1.7999999523162842 3.000100079475487e-08 0.0 3.999999975690116e-08 0.0 4.000100162215858e-08 0.0 5.000000058430487e-08 0.0 )
Vd57_1 d57_1 0 PWL (0.0 0.0 9.999999960041972e-13 0.0 9.99999993922529e-09 0.0 1.0001000028125873e-08 0.0 1.999999987845058e-08 0.0 2.0000999967351163e-08 0.0 2.999999892949745e-08 0.0 3.000100079475487e-08 0.0 3.999999975690116e-08 0.0 4.000100162215858e-08 1.7999999523162842 5.000000058430487e-08 1.7999999523162842 )
Vd57_2 d57_2 0 PWL (0.0 0.0 9.999999960041972e-13 1.7999999523162842 9.99999993922529e-09 1.7999999523162842 1.0001000028125873e-08 0.0 1.999999987845058e-08 0.0 2.0000999967351163e-08 0.0 2.999999892949745e-08 0.0 3.000100079475487e-08 0.0 3.999999975690116e-08 0.0 4.000100162215858e-08 1.7999999523162842 5.000000058430487e-08 1.7999999523162842 )
Vd57_3 d57_3 0 PWL (0.0 0.0 9.999999960041972e-13 1.7999999523162842 9.99999993922529e-09 1.7999999523162842 1.0001000028125873e-08 0.0 1.999999987845058e-08 0.0 2.0000999967351163e-08 1.7999999523162842 2.999999892949745e-08 1.7999999523162842 3.000100079475487e-08 0.0 3.999999975690116e-08 0.0 4.000100162215858e-08 0.0 5.000000058430487e-08 0.0 )
Vd57_4 d57_4 0 PWL (0.0 0.0 9.999999960041972e-13 0.0 9.99999993922529e-09 0.0 1.0001000028125873e-08 1.7999999523162842 1.999999987845058e-08 1.7999999523162842 2.0000999967351163e-08 0.0 2.999999892949745e-08 0.0 3.000100079475487e-08 1.7999999523162842 3.999999975690116e-08 1.7999999523162842 4.000100162215858e-08 0.0 5.000000058430487e-08 0.0 )
Vd57_5 d57_5 0 PWL (0.0 0.0 9.999999960041972e-13 0.0 9.99999993922529e-09 0.0 1.0001000028125873e-08 0.0 1.999999987845058e-08 0.0 2.0000999967351163e-08 0.0 2.999999892949745e-08 0.0 3.000100079475487e-08 0.0 3.999999975690116e-08 0.0 4.000100162215858e-08 1.7999999523162842 5.000000058430487e-08 1.7999999523162842 )
Vd57_6 d57_6 0 PWL (0.0 0.0 9.999999960041972e-13 1.7999999523162842 9.99999993922529e-09 1.7999999523162842 1.0001000028125873e-08 0.0 1.999999987845058e-08 0.0 2.0000999967351163e-08 0.0 2.999999892949745e-08 0.0 3.000100079475487e-08 1.7999999523162842 3.999999975690116e-08 1.7999999523162842 4.000100162215858e-08 1.7999999523162842 5.000000058430487e-08 1.7999999523162842 )
Vd57_7 d57_7 0 PWL (0.0 0.0 9.999999960041972e-13 1.7999999523162842 9.99999993922529e-09 1.7999999523162842 1.0001000028125873e-08 1.7999999523162842 1.999999987845058e-08 1.7999999523162842 2.0000999967351163e-08 0.0 2.999999892949745e-08 0.0 3.000100079475487e-08 0.0 3.999999975690116e-08 0.0 4.000100162215858e-08 0.0 5.000000058430487e-08 0.0 )

    * DAC for operand fed to nac_v0_c3
x58_1 vrefh net-_x58_1-pad2_ d58_0 d58_1 d58_2 d58_3 d58_4 d58_5 d58_6 vdd net-_x58_1-pad11_ s7bit_DAC
x58_2 net-_x58_1-pad2_ vrefl d58_0 d58_1 d58_2 d58_3 d58_4 d58_5 d58_6 vdd net-_x58_2-pad11_ s7bit_DAC
x58_3 d58_7 vdd net-_x58_1-pad11_ net-_x58_2-pad11_ nac_v0_c3 switch

Vd58_0 d58_0 0 PWL (0.0 0.0 9.999999960041972e-13 1.7999999523162842 9.99999993922529e-09 1.7999999523162842 1.0001000028125873e-08 1.7999999523162842 1.999999987845058e-08 1.7999999523162842 2.0000999967351163e-08 1.7999999523162842 2.999999892949745e-08 1.7999999523162842 3.000100079475487e-08 0.0 3.999999975690116e-08 0.0 4.000100162215858e-08 0.0 5.000000058430487e-08 0.0 )
Vd58_1 d58_1 0 PWL (0.0 0.0 9.999999960041972e-13 1.7999999523162842 9.99999993922529e-09 1.7999999523162842 1.0001000028125873e-08 1.7999999523162842 1.999999987845058e-08 1.7999999523162842 2.0000999967351163e-08 1.7999999523162842 2.999999892949745e-08 1.7999999523162842 3.000100079475487e-08 0.0 3.999999975690116e-08 0.0 4.000100162215858e-08 1.7999999523162842 5.000000058430487e-08 1.7999999523162842 )
Vd58_2 d58_2 0 PWL (0.0 0.0 9.999999960041972e-13 1.7999999523162842 9.99999993922529e-09 1.7999999523162842 1.0001000028125873e-08 1.7999999523162842 1.999999987845058e-08 1.7999999523162842 2.0000999967351163e-08 1.7999999523162842 2.999999892949745e-08 1.7999999523162842 3.000100079475487e-08 0.0 3.999999975690116e-08 0.0 4.000100162215858e-08 1.7999999523162842 5.000000058430487e-08 1.7999999523162842 )
Vd58_3 d58_3 0 PWL (0.0 0.0 9.999999960041972e-13 0.0 9.99999993922529e-09 0.0 1.0001000028125873e-08 0.0 1.999999987845058e-08 0.0 2.0000999967351163e-08 1.7999999523162842 2.999999892949745e-08 1.7999999523162842 3.000100079475487e-08 1.7999999523162842 3.999999975690116e-08 1.7999999523162842 4.000100162215858e-08 0.0 5.000000058430487e-08 0.0 )
Vd58_4 d58_4 0 PWL (0.0 0.0 9.999999960041972e-13 0.0 9.99999993922529e-09 0.0 1.0001000028125873e-08 1.7999999523162842 1.999999987845058e-08 1.7999999523162842 2.0000999967351163e-08 1.7999999523162842 2.999999892949745e-08 1.7999999523162842 3.000100079475487e-08 0.0 3.999999975690116e-08 0.0 4.000100162215858e-08 0.0 5.000000058430487e-08 0.0 )
Vd58_5 d58_5 0 PWL (0.0 0.0 9.999999960041972e-13 0.0 9.99999993922529e-09 0.0 1.0001000028125873e-08 0.0 1.999999987845058e-08 0.0 2.0000999967351163e-08 1.7999999523162842 2.999999892949745e-08 1.7999999523162842 3.000100079475487e-08 0.0 3.999999975690116e-08 0.0 4.000100162215858e-08 1.7999999523162842 5.000000058430487e-08 1.7999999523162842 )
Vd58_6 d58_6 0 PWL (0.0 0.0 9.999999960041972e-13 1.7999999523162842 9.99999993922529e-09 1.7999999523162842 1.0001000028125873e-08 0.0 1.999999987845058e-08 0.0 2.0000999967351163e-08 1.7999999523162842 2.999999892949745e-08 1.7999999523162842 3.000100079475487e-08 0.0 3.999999975690116e-08 0.0 4.000100162215858e-08 0.0 5.000000058430487e-08 0.0 )
Vd58_7 d58_7 0 PWL (0.0 0.0 9.999999960041972e-13 1.7999999523162842 9.99999993922529e-09 1.7999999523162842 1.0001000028125873e-08 1.7999999523162842 1.999999987845058e-08 1.7999999523162842 2.0000999967351163e-08 1.7999999523162842 2.999999892949745e-08 1.7999999523162842 3.000100079475487e-08 0.0 3.999999975690116e-08 0.0 4.000100162215858e-08 1.7999999523162842 5.000000058430487e-08 1.7999999523162842 )

    * DAC for operand fed to nac_v1_c3
x59_1 vrefh net-_x59_1-pad2_ d59_0 d59_1 d59_2 d59_3 d59_4 d59_5 d59_6 vdd net-_x59_1-pad11_ s7bit_DAC
x59_2 net-_x59_1-pad2_ vrefl d59_0 d59_1 d59_2 d59_3 d59_4 d59_5 d59_6 vdd net-_x59_2-pad11_ s7bit_DAC
x59_3 d59_7 vdd net-_x59_1-pad11_ net-_x59_2-pad11_ nac_v1_c3 switch

Vd59_0 d59_0 0 PWL (0.0 0.0 9.999999960041972e-13 1.7999999523162842 9.99999993922529e-09 1.7999999523162842 1.0001000028125873e-08 1.7999999523162842 1.999999987845058e-08 1.7999999523162842 2.0000999967351163e-08 1.7999999523162842 2.999999892949745e-08 1.7999999523162842 3.000100079475487e-08 1.7999999523162842 3.999999975690116e-08 1.7999999523162842 4.000100162215858e-08 1.7999999523162842 5.000000058430487e-08 1.7999999523162842 )
Vd59_1 d59_1 0 PWL (0.0 0.0 9.999999960041972e-13 1.7999999523162842 9.99999993922529e-09 1.7999999523162842 1.0001000028125873e-08 0.0 1.999999987845058e-08 0.0 2.0000999967351163e-08 0.0 2.999999892949745e-08 0.0 3.000100079475487e-08 1.7999999523162842 3.999999975690116e-08 1.7999999523162842 4.000100162215858e-08 0.0 5.000000058430487e-08 0.0 )
Vd59_2 d59_2 0 PWL (0.0 0.0 9.999999960041972e-13 1.7999999523162842 9.99999993922529e-09 1.7999999523162842 1.0001000028125873e-08 1.7999999523162842 1.999999987845058e-08 1.7999999523162842 2.0000999967351163e-08 1.7999999523162842 2.999999892949745e-08 1.7999999523162842 3.000100079475487e-08 0.0 3.999999975690116e-08 0.0 4.000100162215858e-08 1.7999999523162842 5.000000058430487e-08 1.7999999523162842 )
Vd59_3 d59_3 0 PWL (0.0 0.0 9.999999960041972e-13 0.0 9.99999993922529e-09 0.0 1.0001000028125873e-08 0.0 1.999999987845058e-08 0.0 2.0000999967351163e-08 1.7999999523162842 2.999999892949745e-08 1.7999999523162842 3.000100079475487e-08 1.7999999523162842 3.999999975690116e-08 1.7999999523162842 4.000100162215858e-08 1.7999999523162842 5.000000058430487e-08 1.7999999523162842 )
Vd59_4 d59_4 0 PWL (0.0 0.0 9.999999960041972e-13 0.0 9.99999993922529e-09 0.0 1.0001000028125873e-08 0.0 1.999999987845058e-08 0.0 2.0000999967351163e-08 0.0 2.999999892949745e-08 0.0 3.000100079475487e-08 1.7999999523162842 3.999999975690116e-08 1.7999999523162842 4.000100162215858e-08 0.0 5.000000058430487e-08 0.0 )
Vd59_5 d59_5 0 PWL (0.0 0.0 9.999999960041972e-13 1.7999999523162842 9.99999993922529e-09 1.7999999523162842 1.0001000028125873e-08 0.0 1.999999987845058e-08 0.0 2.0000999967351163e-08 1.7999999523162842 2.999999892949745e-08 1.7999999523162842 3.000100079475487e-08 0.0 3.999999975690116e-08 0.0 4.000100162215858e-08 1.7999999523162842 5.000000058430487e-08 1.7999999523162842 )
Vd59_6 d59_6 0 PWL (0.0 0.0 9.999999960041972e-13 0.0 9.99999993922529e-09 0.0 1.0001000028125873e-08 1.7999999523162842 1.999999987845058e-08 1.7999999523162842 2.0000999967351163e-08 0.0 2.999999892949745e-08 0.0 3.000100079475487e-08 1.7999999523162842 3.999999975690116e-08 1.7999999523162842 4.000100162215858e-08 1.7999999523162842 5.000000058430487e-08 1.7999999523162842 )
Vd59_7 d59_7 0 PWL (0.0 0.0 9.999999960041972e-13 1.7999999523162842 9.99999993922529e-09 1.7999999523162842 1.0001000028125873e-08 0.0 1.999999987845058e-08 0.0 2.0000999967351163e-08 1.7999999523162842 2.999999892949745e-08 1.7999999523162842 3.000100079475487e-08 1.7999999523162842 3.999999975690116e-08 1.7999999523162842 4.000100162215858e-08 0.0 5.000000058430487e-08 0.0 )
r60 m00_up 0 10000.0
r61 m00_do 0 10000.0
r62 m01_up 0 10000.0
r63 m01_do 0 10000.0
r64 m10_up 0 10000.0
r65 m10_do 0 10000.0
r66 m11_up 0 10000.0
r67 m11_do 0 10000.0
.tran 0 5.000000058430487e-08 100
.print tran v(m00_up) v(m00_do) v(m01_up) v(m01_do) v(m10_up) v(m10_do) v(m11_up) v(m11_do)
.photonic

ps0 n00_do nd00_1 ps=-0.5pi
mzi1 n00_up nd00_1 nd00_2 nd00_3 theta=0.25pi
pd2 nd00_2 m00_up level2 r0=0.001 std=0.05
pd3 nd00_3 m00_do level2 r0=0.001 std=0.05

ps4 n01_do nd01_1 ps=-0.5pi
mzi5 n01_up nd01_1 nd01_2 nd01_3 theta=0.25pi
pd6 nd01_2 m01_up level2 r0=0.001 std=0.05
pd7 nd01_3 m01_do level2 r0=0.001 std=0.05

ps8 n10_do nd10_1 ps=-0.5pi
mzi9 n10_up nd10_1 nd10_2 nd10_3 theta=0.25pi
pd10 nd10_2 m10_up level2 r0=0.001 std=0.05
pd11 nd10_3 m10_do level2 r0=0.001 std=0.05

ps12 n11_do nd11_1 ps=-0.5pi
mzi13 n11_up nd11_1 nd11_2 nd11_3 theta=0.25pi
pd14 nd11_2 m11_up level2 r0=0.001 std=0.05
pd15 nd11_3 m11_do level2 r0=0.001 std=0.05

wdm1to4_16 h_in0 nd_h0_b_0 nd_h0_b_1 nd_h0_b_2 nd_h0_b_3
wdm1to4_17 nd_h0_bsp nd_h0_a_0 nd_h0_a_1 nd_h0_a_2 nd_h0_a_3
splitter1to2_18 nd_h0_bsp n00_up n01_up
modm19 nd_h0_b_0  nd_h0_dummy_0 nd_h0_a_0 nd_h0_dummy_1 nac_h0_c0 level1 coeff1=0.001 act_l=0.0002 alpha = 1.0
modm20 nd_h0_b_1  nd_h0_dummy_2 nd_h0_a_1 nd_h0_dummy_3 nac_h0_c1 level1 coeff1=0.001 act_l=0.0002 alpha = 1.0
modm21 nd_h0_b_2  nd_h0_dummy_4 nd_h0_a_2 nd_h0_dummy_5 nac_h0_c2 level1 coeff1=0.001 act_l=0.0002 alpha = 1.0
modm22 nd_h0_b_3  nd_h0_dummy_6 nd_h0_a_3 nd_h0_dummy_7 nac_h0_c3 level1 coeff1=0.001 act_l=0.0002 alpha = 1.0

wdm1to4_23 h_in1 nd_h1_b_0 nd_h1_b_1 nd_h1_b_2 nd_h1_b_3
wdm1to4_24 nd_h1_bsp nd_h1_a_0 nd_h1_a_1 nd_h1_a_2 nd_h1_a_3
splitter1to2_25 nd_h1_bsp n10_up n11_up
modm26 nd_h1_b_0  nd_h1_dummy_0 nd_h1_a_0 nd_h1_dummy_1 nac_h1_c0 level1 coeff1=0.001 act_l=0.0002 alpha = 1.0
modm27 nd_h1_b_1  nd_h1_dummy_2 nd_h1_a_1 nd_h1_dummy_3 nac_h1_c1 level1 coeff1=0.001 act_l=0.0002 alpha = 1.0
modm28 nd_h1_b_2  nd_h1_dummy_4 nd_h1_a_2 nd_h1_dummy_5 nac_h1_c2 level1 coeff1=0.001 act_l=0.0002 alpha = 1.0
modm29 nd_h1_b_3  nd_h1_dummy_6 nd_h1_a_3 nd_h1_dummy_7 nac_h1_c3 level1 coeff1=0.001 act_l=0.0002 alpha = 1.0

wdm1to4_30 v_in0 nd_v0_b_0 nd_v0_b_1 nd_v0_b_2 nd_v0_b_3
wdm1to4_31 nd_v0_bsp nd_v0_a_0 nd_v0_a_1 nd_v0_a_2 nd_v0_a_3
splitter1to2_32 nd_v0_bsp n00_do n10_do
modm33 nd_v0_b_0  nd_v0_dummy_0 nd_v0_a_0 nd_v0_dummy_1 nac_v0_c0 level1 coeff1=0.001 act_l=0.0002 alpha = 1.0
modm34 nd_v0_b_1  nd_v0_dummy_2 nd_v0_a_1 nd_v0_dummy_3 nac_v0_c1 level1 coeff1=0.001 act_l=0.0002 alpha = 1.0
modm35 nd_v0_b_2  nd_v0_dummy_4 nd_v0_a_2 nd_v0_dummy_5 nac_v0_c2 level1 coeff1=0.001 act_l=0.0002 alpha = 1.0
modm36 nd_v0_b_3  nd_v0_dummy_6 nd_v0_a_3 nd_v0_dummy_7 nac_v0_c3 level1 coeff1=0.001 act_l=0.0002 alpha = 1.0

wdm1to4_37 v_in1 nd_v1_b_0 nd_v1_b_1 nd_v1_b_2 nd_v1_b_3
wdm1to4_38 nd_v1_bsp nd_v1_a_0 nd_v1_a_1 nd_v1_a_2 nd_v1_a_3
splitter1to2_39 nd_v1_bsp n01_do n11_do
modm40 nd_v1_b_0  nd_v1_dummy_0 nd_v1_a_0 nd_v1_dummy_1 nac_v1_c0 level1 coeff1=0.001 act_l=0.0002 alpha = 1.0
modm41 nd_v1_b_1  nd_v1_dummy_2 nd_v1_a_1 nd_v1_dummy_3 nac_v1_c1 level1 coeff1=0.001 act_l=0.0002 alpha = 1.0
modm42 nd_v1_b_2  nd_v1_dummy_4 nd_v1_a_2 nd_v1_dummy_5 nac_v1_c2 level1 coeff1=0.001 act_l=0.0002 alpha = 1.0
modm43 nd_v1_b_3  nd_v1_dummy_6 nd_v1_a_3 nd_v1_dummy_7 nac_v1_c3 level1 coeff1=0.001 act_l=0.0002 alpha = 1.0

        .mode neff=2.35
        .freq 193500000000000.0 193500000000000.0 4
        .source 1.0@h_in0 1.0@h_in1 1.0@v_in0 1.0@v_in1 power=0.005w eff=0.2
        .prob nd_h0_bsp n00_up
        .end
