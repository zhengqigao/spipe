.electronic

    * DAC for operand fed to m_0
x4_1 vrefh net-_x4_1-pad2_ d4_0 d4_1 d4_2 d4_3 d4_4 d4_5 d4_6 vdd net-_x4_1-pad11_ s7bit_DAC
x4_2 net-_x4_1-pad2_ vrefl d4_0 d4_1 d4_2 d4_3 d4_4 d4_5 d4_6 vdd net-_x4_2-pad11_ s7bit_DAC
x4_3 d4_7 vdd net-_x4_1-pad11_ net-_x4_2-pad11_ m_0 switch

Vd4_0 d4_0 0 PWL (0.0 0.0 9.999999960041972e-13 0.0 9.99999993922529e-09 0.0 1.0001000028125873e-08 1.7999999523162842 1.999999987845058e-08 1.7999999523162842 2.0000999967351163e-08 1.7999999523162842 2.999999892949745e-08 1.7999999523162842 3.000100079475487e-08 1.7999999523162842 3.999999975690116e-08 1.7999999523162842 4.000100162215858e-08 1.7999999523162842 5.000000058430487e-08 1.7999999523162842 )
Vd4_1 d4_1 0 PWL (0.0 0.0 9.999999960041972e-13 0.0 9.99999993922529e-09 0.0 1.0001000028125873e-08 1.7999999523162842 1.999999987845058e-08 1.7999999523162842 2.0000999967351163e-08 1.7999999523162842 2.999999892949745e-08 1.7999999523162842 3.000100079475487e-08 1.7999999523162842 3.999999975690116e-08 1.7999999523162842 4.000100162215858e-08 1.7999999523162842 5.000000058430487e-08 1.7999999523162842 )
Vd4_2 d4_2 0 PWL (0.0 0.0 9.999999960041972e-13 0.0 9.99999993922529e-09 0.0 1.0001000028125873e-08 1.7999999523162842 1.999999987845058e-08 1.7999999523162842 2.0000999967351163e-08 1.7999999523162842 2.999999892949745e-08 1.7999999523162842 3.000100079475487e-08 1.7999999523162842 3.999999975690116e-08 1.7999999523162842 4.000100162215858e-08 1.7999999523162842 5.000000058430487e-08 1.7999999523162842 )
Vd4_3 d4_3 0 PWL (0.0 0.0 9.999999960041972e-13 0.0 9.99999993922529e-09 0.0 1.0001000028125873e-08 1.7999999523162842 1.999999987845058e-08 1.7999999523162842 2.0000999967351163e-08 1.7999999523162842 2.999999892949745e-08 1.7999999523162842 3.000100079475487e-08 1.7999999523162842 3.999999975690116e-08 1.7999999523162842 4.000100162215858e-08 1.7999999523162842 5.000000058430487e-08 1.7999999523162842 )
Vd4_4 d4_4 0 PWL (0.0 0.0 9.999999960041972e-13 0.0 9.99999993922529e-09 0.0 1.0001000028125873e-08 1.7999999523162842 1.999999987845058e-08 1.7999999523162842 2.0000999967351163e-08 1.7999999523162842 2.999999892949745e-08 1.7999999523162842 3.000100079475487e-08 1.7999999523162842 3.999999975690116e-08 1.7999999523162842 4.000100162215858e-08 1.7999999523162842 5.000000058430487e-08 1.7999999523162842 )
Vd4_5 d4_5 0 PWL (0.0 0.0 9.999999960041972e-13 0.0 9.99999993922529e-09 0.0 1.0001000028125873e-08 1.7999999523162842 1.999999987845058e-08 1.7999999523162842 2.0000999967351163e-08 1.7999999523162842 2.999999892949745e-08 1.7999999523162842 3.000100079475487e-08 1.7999999523162842 3.999999975690116e-08 1.7999999523162842 4.000100162215858e-08 1.7999999523162842 5.000000058430487e-08 1.7999999523162842 )
Vd4_6 d4_6 0 PWL (0.0 0.0 9.999999960041972e-13 0.0 9.99999993922529e-09 0.0 1.0001000028125873e-08 0.0 1.999999987845058e-08 0.0 2.0000999967351163e-08 1.7999999523162842 2.999999892949745e-08 1.7999999523162842 3.000100079475487e-08 0.0 3.999999975690116e-08 0.0 4.000100162215858e-08 1.7999999523162842 5.000000058430487e-08 1.7999999523162842 )
Vd4_7 d4_7 0 PWL (0.0 0.0 9.999999960041972e-13 0.0 9.99999993922529e-09 0.0 1.0001000028125873e-08 0.0 1.999999987845058e-08 0.0 2.0000999967351163e-08 0.0 2.999999892949745e-08 0.0 3.000100079475487e-08 1.7999999523162842 3.999999975690116e-08 1.7999999523162842 4.000100162215858e-08 1.7999999523162842 5.000000058430487e-08 1.7999999523162842 )

    * DAC for operand fed to m_1
x9_1 vrefh net-_x9_1-pad2_ d9_0 d9_1 d9_2 d9_3 d9_4 d9_5 d9_6 vdd net-_x9_1-pad11_ s7bit_DAC
x9_2 net-_x9_1-pad2_ vrefl d9_0 d9_1 d9_2 d9_3 d9_4 d9_5 d9_6 vdd net-_x9_2-pad11_ s7bit_DAC
x9_3 d9_7 vdd net-_x9_1-pad11_ net-_x9_2-pad11_ m_1 switch

Vd9_0 d9_0 0 PWL (0.0 0.0 9.999999960041972e-13 0.0 9.99999993922529e-09 0.0 1.0001000028125873e-08 1.7999999523162842 1.999999987845058e-08 1.7999999523162842 2.0000999967351163e-08 1.7999999523162842 2.999999892949745e-08 1.7999999523162842 3.000100079475487e-08 1.7999999523162842 3.999999975690116e-08 1.7999999523162842 4.000100162215858e-08 1.7999999523162842 5.000000058430487e-08 1.7999999523162842 )
Vd9_1 d9_1 0 PWL (0.0 0.0 9.999999960041972e-13 0.0 9.99999993922529e-09 0.0 1.0001000028125873e-08 1.7999999523162842 1.999999987845058e-08 1.7999999523162842 2.0000999967351163e-08 1.7999999523162842 2.999999892949745e-08 1.7999999523162842 3.000100079475487e-08 1.7999999523162842 3.999999975690116e-08 1.7999999523162842 4.000100162215858e-08 1.7999999523162842 5.000000058430487e-08 1.7999999523162842 )
Vd9_2 d9_2 0 PWL (0.0 0.0 9.999999960041972e-13 0.0 9.99999993922529e-09 0.0 1.0001000028125873e-08 1.7999999523162842 1.999999987845058e-08 1.7999999523162842 2.0000999967351163e-08 1.7999999523162842 2.999999892949745e-08 1.7999999523162842 3.000100079475487e-08 1.7999999523162842 3.999999975690116e-08 1.7999999523162842 4.000100162215858e-08 1.7999999523162842 5.000000058430487e-08 1.7999999523162842 )
Vd9_3 d9_3 0 PWL (0.0 0.0 9.999999960041972e-13 0.0 9.99999993922529e-09 0.0 1.0001000028125873e-08 1.7999999523162842 1.999999987845058e-08 1.7999999523162842 2.0000999967351163e-08 1.7999999523162842 2.999999892949745e-08 1.7999999523162842 3.000100079475487e-08 1.7999999523162842 3.999999975690116e-08 1.7999999523162842 4.000100162215858e-08 1.7999999523162842 5.000000058430487e-08 1.7999999523162842 )
Vd9_4 d9_4 0 PWL (0.0 0.0 9.999999960041972e-13 0.0 9.99999993922529e-09 0.0 1.0001000028125873e-08 1.7999999523162842 1.999999987845058e-08 1.7999999523162842 2.0000999967351163e-08 1.7999999523162842 2.999999892949745e-08 1.7999999523162842 3.000100079475487e-08 1.7999999523162842 3.999999975690116e-08 1.7999999523162842 4.000100162215858e-08 1.7999999523162842 5.000000058430487e-08 1.7999999523162842 )
Vd9_5 d9_5 0 PWL (0.0 0.0 9.999999960041972e-13 0.0 9.99999993922529e-09 0.0 1.0001000028125873e-08 1.7999999523162842 1.999999987845058e-08 1.7999999523162842 2.0000999967351163e-08 1.7999999523162842 2.999999892949745e-08 1.7999999523162842 3.000100079475487e-08 1.7999999523162842 3.999999975690116e-08 1.7999999523162842 4.000100162215858e-08 1.7999999523162842 5.000000058430487e-08 1.7999999523162842 )
Vd9_6 d9_6 0 PWL (0.0 0.0 9.999999960041972e-13 0.0 9.99999993922529e-09 0.0 1.0001000028125873e-08 0.0 1.999999987845058e-08 0.0 2.0000999967351163e-08 1.7999999523162842 2.999999892949745e-08 1.7999999523162842 3.000100079475487e-08 0.0 3.999999975690116e-08 0.0 4.000100162215858e-08 1.7999999523162842 5.000000058430487e-08 1.7999999523162842 )
Vd9_7 d9_7 0 PWL (0.0 0.0 9.999999960041972e-13 0.0 9.99999993922529e-09 0.0 1.0001000028125873e-08 0.0 1.999999987845058e-08 0.0 2.0000999967351163e-08 0.0 2.999999892949745e-08 0.0 3.000100079475487e-08 1.7999999523162842 3.999999975690116e-08 1.7999999523162842 4.000100162215858e-08 1.7999999523162842 5.000000058430487e-08 1.7999999523162842 )

    * DAC for operand fed to m_2
x14_1 vrefh net-_x14_1-pad2_ d14_0 d14_1 d14_2 d14_3 d14_4 d14_5 d14_6 vdd net-_x14_1-pad11_ s7bit_DAC
x14_2 net-_x14_1-pad2_ vrefl d14_0 d14_1 d14_2 d14_3 d14_4 d14_5 d14_6 vdd net-_x14_2-pad11_ s7bit_DAC
x14_3 d14_7 vdd net-_x14_1-pad11_ net-_x14_2-pad11_ m_2 switch

Vd14_0 d14_0 0 PWL (0.0 0.0 9.999999960041972e-13 0.0 9.99999993922529e-09 0.0 1.0001000028125873e-08 1.7999999523162842 1.999999987845058e-08 1.7999999523162842 2.0000999967351163e-08 1.7999999523162842 2.999999892949745e-08 1.7999999523162842 3.000100079475487e-08 1.7999999523162842 3.999999975690116e-08 1.7999999523162842 4.000100162215858e-08 1.7999999523162842 5.000000058430487e-08 1.7999999523162842 )
Vd14_1 d14_1 0 PWL (0.0 0.0 9.999999960041972e-13 0.0 9.99999993922529e-09 0.0 1.0001000028125873e-08 1.7999999523162842 1.999999987845058e-08 1.7999999523162842 2.0000999967351163e-08 1.7999999523162842 2.999999892949745e-08 1.7999999523162842 3.000100079475487e-08 1.7999999523162842 3.999999975690116e-08 1.7999999523162842 4.000100162215858e-08 1.7999999523162842 5.000000058430487e-08 1.7999999523162842 )
Vd14_2 d14_2 0 PWL (0.0 0.0 9.999999960041972e-13 0.0 9.99999993922529e-09 0.0 1.0001000028125873e-08 1.7999999523162842 1.999999987845058e-08 1.7999999523162842 2.0000999967351163e-08 1.7999999523162842 2.999999892949745e-08 1.7999999523162842 3.000100079475487e-08 1.7999999523162842 3.999999975690116e-08 1.7999999523162842 4.000100162215858e-08 1.7999999523162842 5.000000058430487e-08 1.7999999523162842 )
Vd14_3 d14_3 0 PWL (0.0 0.0 9.999999960041972e-13 0.0 9.99999993922529e-09 0.0 1.0001000028125873e-08 1.7999999523162842 1.999999987845058e-08 1.7999999523162842 2.0000999967351163e-08 1.7999999523162842 2.999999892949745e-08 1.7999999523162842 3.000100079475487e-08 1.7999999523162842 3.999999975690116e-08 1.7999999523162842 4.000100162215858e-08 1.7999999523162842 5.000000058430487e-08 1.7999999523162842 )
Vd14_4 d14_4 0 PWL (0.0 0.0 9.999999960041972e-13 0.0 9.99999993922529e-09 0.0 1.0001000028125873e-08 1.7999999523162842 1.999999987845058e-08 1.7999999523162842 2.0000999967351163e-08 1.7999999523162842 2.999999892949745e-08 1.7999999523162842 3.000100079475487e-08 1.7999999523162842 3.999999975690116e-08 1.7999999523162842 4.000100162215858e-08 1.7999999523162842 5.000000058430487e-08 1.7999999523162842 )
Vd14_5 d14_5 0 PWL (0.0 0.0 9.999999960041972e-13 0.0 9.99999993922529e-09 0.0 1.0001000028125873e-08 1.7999999523162842 1.999999987845058e-08 1.7999999523162842 2.0000999967351163e-08 1.7999999523162842 2.999999892949745e-08 1.7999999523162842 3.000100079475487e-08 1.7999999523162842 3.999999975690116e-08 1.7999999523162842 4.000100162215858e-08 1.7999999523162842 5.000000058430487e-08 1.7999999523162842 )
Vd14_6 d14_6 0 PWL (0.0 0.0 9.999999960041972e-13 0.0 9.99999993922529e-09 0.0 1.0001000028125873e-08 0.0 1.999999987845058e-08 0.0 2.0000999967351163e-08 1.7999999523162842 2.999999892949745e-08 1.7999999523162842 3.000100079475487e-08 0.0 3.999999975690116e-08 0.0 4.000100162215858e-08 1.7999999523162842 5.000000058430487e-08 1.7999999523162842 )
Vd14_7 d14_7 0 PWL (0.0 0.0 9.999999960041972e-13 0.0 9.99999993922529e-09 0.0 1.0001000028125873e-08 0.0 1.999999987845058e-08 0.0 2.0000999967351163e-08 0.0 2.999999892949745e-08 0.0 3.000100079475487e-08 1.7999999523162842 3.999999975690116e-08 1.7999999523162842 4.000100162215858e-08 1.7999999523162842 5.000000058430487e-08 1.7999999523162842 )

    * DAC for operand fed to m_3
x19_1 vrefh net-_x19_1-pad2_ d19_0 d19_1 d19_2 d19_3 d19_4 d19_5 d19_6 vdd net-_x19_1-pad11_ s7bit_DAC
x19_2 net-_x19_1-pad2_ vrefl d19_0 d19_1 d19_2 d19_3 d19_4 d19_5 d19_6 vdd net-_x19_2-pad11_ s7bit_DAC
x19_3 d19_7 vdd net-_x19_1-pad11_ net-_x19_2-pad11_ m_3 switch

Vd19_0 d19_0 0 PWL (0.0 0.0 9.999999960041972e-13 0.0 9.99999993922529e-09 0.0 1.0001000028125873e-08 1.7999999523162842 1.999999987845058e-08 1.7999999523162842 2.0000999967351163e-08 1.7999999523162842 2.999999892949745e-08 1.7999999523162842 3.000100079475487e-08 1.7999999523162842 3.999999975690116e-08 1.7999999523162842 4.000100162215858e-08 1.7999999523162842 5.000000058430487e-08 1.7999999523162842 )
Vd19_1 d19_1 0 PWL (0.0 0.0 9.999999960041972e-13 0.0 9.99999993922529e-09 0.0 1.0001000028125873e-08 1.7999999523162842 1.999999987845058e-08 1.7999999523162842 2.0000999967351163e-08 1.7999999523162842 2.999999892949745e-08 1.7999999523162842 3.000100079475487e-08 1.7999999523162842 3.999999975690116e-08 1.7999999523162842 4.000100162215858e-08 1.7999999523162842 5.000000058430487e-08 1.7999999523162842 )
Vd19_2 d19_2 0 PWL (0.0 0.0 9.999999960041972e-13 0.0 9.99999993922529e-09 0.0 1.0001000028125873e-08 1.7999999523162842 1.999999987845058e-08 1.7999999523162842 2.0000999967351163e-08 1.7999999523162842 2.999999892949745e-08 1.7999999523162842 3.000100079475487e-08 1.7999999523162842 3.999999975690116e-08 1.7999999523162842 4.000100162215858e-08 1.7999999523162842 5.000000058430487e-08 1.7999999523162842 )
Vd19_3 d19_3 0 PWL (0.0 0.0 9.999999960041972e-13 0.0 9.99999993922529e-09 0.0 1.0001000028125873e-08 1.7999999523162842 1.999999987845058e-08 1.7999999523162842 2.0000999967351163e-08 1.7999999523162842 2.999999892949745e-08 1.7999999523162842 3.000100079475487e-08 1.7999999523162842 3.999999975690116e-08 1.7999999523162842 4.000100162215858e-08 1.7999999523162842 5.000000058430487e-08 1.7999999523162842 )
Vd19_4 d19_4 0 PWL (0.0 0.0 9.999999960041972e-13 0.0 9.99999993922529e-09 0.0 1.0001000028125873e-08 1.7999999523162842 1.999999987845058e-08 1.7999999523162842 2.0000999967351163e-08 1.7999999523162842 2.999999892949745e-08 1.7999999523162842 3.000100079475487e-08 1.7999999523162842 3.999999975690116e-08 1.7999999523162842 4.000100162215858e-08 1.7999999523162842 5.000000058430487e-08 1.7999999523162842 )
Vd19_5 d19_5 0 PWL (0.0 0.0 9.999999960041972e-13 0.0 9.99999993922529e-09 0.0 1.0001000028125873e-08 1.7999999523162842 1.999999987845058e-08 1.7999999523162842 2.0000999967351163e-08 1.7999999523162842 2.999999892949745e-08 1.7999999523162842 3.000100079475487e-08 1.7999999523162842 3.999999975690116e-08 1.7999999523162842 4.000100162215858e-08 1.7999999523162842 5.000000058430487e-08 1.7999999523162842 )
Vd19_6 d19_6 0 PWL (0.0 0.0 9.999999960041972e-13 0.0 9.99999993922529e-09 0.0 1.0001000028125873e-08 0.0 1.999999987845058e-08 0.0 2.0000999967351163e-08 1.7999999523162842 2.999999892949745e-08 1.7999999523162842 3.000100079475487e-08 0.0 3.999999975690116e-08 0.0 4.000100162215858e-08 1.7999999523162842 5.000000058430487e-08 1.7999999523162842 )
Vd19_7 d19_7 0 PWL (0.0 0.0 9.999999960041972e-13 0.0 9.99999993922529e-09 0.0 1.0001000028125873e-08 0.0 1.999999987845058e-08 0.0 2.0000999967351163e-08 0.0 2.999999892949745e-08 0.0 3.000100079475487e-08 1.7999999523162842 3.999999975690116e-08 1.7999999523162842 4.000100162215858e-08 1.7999999523162842 5.000000058430487e-08 1.7999999523162842 )

    * DAC for operand fed to m_4
x24_1 vrefh net-_x24_1-pad2_ d24_0 d24_1 d24_2 d24_3 d24_4 d24_5 d24_6 vdd net-_x24_1-pad11_ s7bit_DAC
x24_2 net-_x24_1-pad2_ vrefl d24_0 d24_1 d24_2 d24_3 d24_4 d24_5 d24_6 vdd net-_x24_2-pad11_ s7bit_DAC
x24_3 d24_7 vdd net-_x24_1-pad11_ net-_x24_2-pad11_ m_4 switch

Vd24_0 d24_0 0 PWL (0.0 0.0 9.999999960041972e-13 0.0 9.99999993922529e-09 0.0 1.0001000028125873e-08 1.7999999523162842 1.999999987845058e-08 1.7999999523162842 2.0000999967351163e-08 1.7999999523162842 2.999999892949745e-08 1.7999999523162842 3.000100079475487e-08 1.7999999523162842 3.999999975690116e-08 1.7999999523162842 4.000100162215858e-08 1.7999999523162842 5.000000058430487e-08 1.7999999523162842 )
Vd24_1 d24_1 0 PWL (0.0 0.0 9.999999960041972e-13 0.0 9.99999993922529e-09 0.0 1.0001000028125873e-08 1.7999999523162842 1.999999987845058e-08 1.7999999523162842 2.0000999967351163e-08 1.7999999523162842 2.999999892949745e-08 1.7999999523162842 3.000100079475487e-08 1.7999999523162842 3.999999975690116e-08 1.7999999523162842 4.000100162215858e-08 1.7999999523162842 5.000000058430487e-08 1.7999999523162842 )
Vd24_2 d24_2 0 PWL (0.0 0.0 9.999999960041972e-13 0.0 9.99999993922529e-09 0.0 1.0001000028125873e-08 1.7999999523162842 1.999999987845058e-08 1.7999999523162842 2.0000999967351163e-08 1.7999999523162842 2.999999892949745e-08 1.7999999523162842 3.000100079475487e-08 1.7999999523162842 3.999999975690116e-08 1.7999999523162842 4.000100162215858e-08 1.7999999523162842 5.000000058430487e-08 1.7999999523162842 )
Vd24_3 d24_3 0 PWL (0.0 0.0 9.999999960041972e-13 0.0 9.99999993922529e-09 0.0 1.0001000028125873e-08 1.7999999523162842 1.999999987845058e-08 1.7999999523162842 2.0000999967351163e-08 1.7999999523162842 2.999999892949745e-08 1.7999999523162842 3.000100079475487e-08 1.7999999523162842 3.999999975690116e-08 1.7999999523162842 4.000100162215858e-08 1.7999999523162842 5.000000058430487e-08 1.7999999523162842 )
Vd24_4 d24_4 0 PWL (0.0 0.0 9.999999960041972e-13 0.0 9.99999993922529e-09 0.0 1.0001000028125873e-08 1.7999999523162842 1.999999987845058e-08 1.7999999523162842 2.0000999967351163e-08 1.7999999523162842 2.999999892949745e-08 1.7999999523162842 3.000100079475487e-08 1.7999999523162842 3.999999975690116e-08 1.7999999523162842 4.000100162215858e-08 1.7999999523162842 5.000000058430487e-08 1.7999999523162842 )
Vd24_5 d24_5 0 PWL (0.0 0.0 9.999999960041972e-13 0.0 9.99999993922529e-09 0.0 1.0001000028125873e-08 1.7999999523162842 1.999999987845058e-08 1.7999999523162842 2.0000999967351163e-08 1.7999999523162842 2.999999892949745e-08 1.7999999523162842 3.000100079475487e-08 1.7999999523162842 3.999999975690116e-08 1.7999999523162842 4.000100162215858e-08 1.7999999523162842 5.000000058430487e-08 1.7999999523162842 )
Vd24_6 d24_6 0 PWL (0.0 0.0 9.999999960041972e-13 0.0 9.99999993922529e-09 0.0 1.0001000028125873e-08 0.0 1.999999987845058e-08 0.0 2.0000999967351163e-08 1.7999999523162842 2.999999892949745e-08 1.7999999523162842 3.000100079475487e-08 0.0 3.999999975690116e-08 0.0 4.000100162215858e-08 1.7999999523162842 5.000000058430487e-08 1.7999999523162842 )
Vd24_7 d24_7 0 PWL (0.0 0.0 9.999999960041972e-13 0.0 9.99999993922529e-09 0.0 1.0001000028125873e-08 0.0 1.999999987845058e-08 0.0 2.0000999967351163e-08 0.0 2.999999892949745e-08 0.0 3.000100079475487e-08 1.7999999523162842 3.999999975690116e-08 1.7999999523162842 4.000100162215858e-08 1.7999999523162842 5.000000058430487e-08 1.7999999523162842 )

    * DAC for operand fed to m_5
x29_1 vrefh net-_x29_1-pad2_ d29_0 d29_1 d29_2 d29_3 d29_4 d29_5 d29_6 vdd net-_x29_1-pad11_ s7bit_DAC
x29_2 net-_x29_1-pad2_ vrefl d29_0 d29_1 d29_2 d29_3 d29_4 d29_5 d29_6 vdd net-_x29_2-pad11_ s7bit_DAC
x29_3 d29_7 vdd net-_x29_1-pad11_ net-_x29_2-pad11_ m_5 switch

Vd29_0 d29_0 0 PWL (0.0 0.0 9.999999960041972e-13 0.0 9.99999993922529e-09 0.0 1.0001000028125873e-08 1.7999999523162842 1.999999987845058e-08 1.7999999523162842 2.0000999967351163e-08 1.7999999523162842 2.999999892949745e-08 1.7999999523162842 3.000100079475487e-08 1.7999999523162842 3.999999975690116e-08 1.7999999523162842 4.000100162215858e-08 1.7999999523162842 5.000000058430487e-08 1.7999999523162842 )
Vd29_1 d29_1 0 PWL (0.0 0.0 9.999999960041972e-13 0.0 9.99999993922529e-09 0.0 1.0001000028125873e-08 1.7999999523162842 1.999999987845058e-08 1.7999999523162842 2.0000999967351163e-08 1.7999999523162842 2.999999892949745e-08 1.7999999523162842 3.000100079475487e-08 1.7999999523162842 3.999999975690116e-08 1.7999999523162842 4.000100162215858e-08 1.7999999523162842 5.000000058430487e-08 1.7999999523162842 )
Vd29_2 d29_2 0 PWL (0.0 0.0 9.999999960041972e-13 0.0 9.99999993922529e-09 0.0 1.0001000028125873e-08 1.7999999523162842 1.999999987845058e-08 1.7999999523162842 2.0000999967351163e-08 1.7999999523162842 2.999999892949745e-08 1.7999999523162842 3.000100079475487e-08 1.7999999523162842 3.999999975690116e-08 1.7999999523162842 4.000100162215858e-08 1.7999999523162842 5.000000058430487e-08 1.7999999523162842 )
Vd29_3 d29_3 0 PWL (0.0 0.0 9.999999960041972e-13 0.0 9.99999993922529e-09 0.0 1.0001000028125873e-08 1.7999999523162842 1.999999987845058e-08 1.7999999523162842 2.0000999967351163e-08 1.7999999523162842 2.999999892949745e-08 1.7999999523162842 3.000100079475487e-08 1.7999999523162842 3.999999975690116e-08 1.7999999523162842 4.000100162215858e-08 1.7999999523162842 5.000000058430487e-08 1.7999999523162842 )
Vd29_4 d29_4 0 PWL (0.0 0.0 9.999999960041972e-13 0.0 9.99999993922529e-09 0.0 1.0001000028125873e-08 1.7999999523162842 1.999999987845058e-08 1.7999999523162842 2.0000999967351163e-08 1.7999999523162842 2.999999892949745e-08 1.7999999523162842 3.000100079475487e-08 1.7999999523162842 3.999999975690116e-08 1.7999999523162842 4.000100162215858e-08 1.7999999523162842 5.000000058430487e-08 1.7999999523162842 )
Vd29_5 d29_5 0 PWL (0.0 0.0 9.999999960041972e-13 0.0 9.99999993922529e-09 0.0 1.0001000028125873e-08 1.7999999523162842 1.999999987845058e-08 1.7999999523162842 2.0000999967351163e-08 1.7999999523162842 2.999999892949745e-08 1.7999999523162842 3.000100079475487e-08 1.7999999523162842 3.999999975690116e-08 1.7999999523162842 4.000100162215858e-08 1.7999999523162842 5.000000058430487e-08 1.7999999523162842 )
Vd29_6 d29_6 0 PWL (0.0 0.0 9.999999960041972e-13 0.0 9.99999993922529e-09 0.0 1.0001000028125873e-08 0.0 1.999999987845058e-08 0.0 2.0000999967351163e-08 1.7999999523162842 2.999999892949745e-08 1.7999999523162842 3.000100079475487e-08 0.0 3.999999975690116e-08 0.0 4.000100162215858e-08 1.7999999523162842 5.000000058430487e-08 1.7999999523162842 )
Vd29_7 d29_7 0 PWL (0.0 0.0 9.999999960041972e-13 0.0 9.99999993922529e-09 0.0 1.0001000028125873e-08 0.0 1.999999987845058e-08 0.0 2.0000999967351163e-08 0.0 2.999999892949745e-08 0.0 3.000100079475487e-08 1.7999999523162842 3.999999975690116e-08 1.7999999523162842 4.000100162215858e-08 1.7999999523162842 5.000000058430487e-08 1.7999999523162842 )

    * DAC for operand fed to m_6
x34_1 vrefh net-_x34_1-pad2_ d34_0 d34_1 d34_2 d34_3 d34_4 d34_5 d34_6 vdd net-_x34_1-pad11_ s7bit_DAC
x34_2 net-_x34_1-pad2_ vrefl d34_0 d34_1 d34_2 d34_3 d34_4 d34_5 d34_6 vdd net-_x34_2-pad11_ s7bit_DAC
x34_3 d34_7 vdd net-_x34_1-pad11_ net-_x34_2-pad11_ m_6 switch

Vd34_0 d34_0 0 PWL (0.0 0.0 9.999999960041972e-13 0.0 9.99999993922529e-09 0.0 1.0001000028125873e-08 1.7999999523162842 1.999999987845058e-08 1.7999999523162842 2.0000999967351163e-08 1.7999999523162842 2.999999892949745e-08 1.7999999523162842 3.000100079475487e-08 1.7999999523162842 3.999999975690116e-08 1.7999999523162842 4.000100162215858e-08 1.7999999523162842 5.000000058430487e-08 1.7999999523162842 )
Vd34_1 d34_1 0 PWL (0.0 0.0 9.999999960041972e-13 0.0 9.99999993922529e-09 0.0 1.0001000028125873e-08 1.7999999523162842 1.999999987845058e-08 1.7999999523162842 2.0000999967351163e-08 1.7999999523162842 2.999999892949745e-08 1.7999999523162842 3.000100079475487e-08 1.7999999523162842 3.999999975690116e-08 1.7999999523162842 4.000100162215858e-08 1.7999999523162842 5.000000058430487e-08 1.7999999523162842 )
Vd34_2 d34_2 0 PWL (0.0 0.0 9.999999960041972e-13 0.0 9.99999993922529e-09 0.0 1.0001000028125873e-08 1.7999999523162842 1.999999987845058e-08 1.7999999523162842 2.0000999967351163e-08 1.7999999523162842 2.999999892949745e-08 1.7999999523162842 3.000100079475487e-08 1.7999999523162842 3.999999975690116e-08 1.7999999523162842 4.000100162215858e-08 1.7999999523162842 5.000000058430487e-08 1.7999999523162842 )
Vd34_3 d34_3 0 PWL (0.0 0.0 9.999999960041972e-13 0.0 9.99999993922529e-09 0.0 1.0001000028125873e-08 1.7999999523162842 1.999999987845058e-08 1.7999999523162842 2.0000999967351163e-08 1.7999999523162842 2.999999892949745e-08 1.7999999523162842 3.000100079475487e-08 1.7999999523162842 3.999999975690116e-08 1.7999999523162842 4.000100162215858e-08 1.7999999523162842 5.000000058430487e-08 1.7999999523162842 )
Vd34_4 d34_4 0 PWL (0.0 0.0 9.999999960041972e-13 0.0 9.99999993922529e-09 0.0 1.0001000028125873e-08 1.7999999523162842 1.999999987845058e-08 1.7999999523162842 2.0000999967351163e-08 1.7999999523162842 2.999999892949745e-08 1.7999999523162842 3.000100079475487e-08 1.7999999523162842 3.999999975690116e-08 1.7999999523162842 4.000100162215858e-08 1.7999999523162842 5.000000058430487e-08 1.7999999523162842 )
Vd34_5 d34_5 0 PWL (0.0 0.0 9.999999960041972e-13 0.0 9.99999993922529e-09 0.0 1.0001000028125873e-08 1.7999999523162842 1.999999987845058e-08 1.7999999523162842 2.0000999967351163e-08 1.7999999523162842 2.999999892949745e-08 1.7999999523162842 3.000100079475487e-08 1.7999999523162842 3.999999975690116e-08 1.7999999523162842 4.000100162215858e-08 1.7999999523162842 5.000000058430487e-08 1.7999999523162842 )
Vd34_6 d34_6 0 PWL (0.0 0.0 9.999999960041972e-13 0.0 9.99999993922529e-09 0.0 1.0001000028125873e-08 0.0 1.999999987845058e-08 0.0 2.0000999967351163e-08 1.7999999523162842 2.999999892949745e-08 1.7999999523162842 3.000100079475487e-08 0.0 3.999999975690116e-08 0.0 4.000100162215858e-08 1.7999999523162842 5.000000058430487e-08 1.7999999523162842 )
Vd34_7 d34_7 0 PWL (0.0 0.0 9.999999960041972e-13 0.0 9.99999993922529e-09 0.0 1.0001000028125873e-08 0.0 1.999999987845058e-08 0.0 2.0000999967351163e-08 0.0 2.999999892949745e-08 0.0 3.000100079475487e-08 1.7999999523162842 3.999999975690116e-08 1.7999999523162842 4.000100162215858e-08 1.7999999523162842 5.000000058430487e-08 1.7999999523162842 )

    * DAC for operand fed to m_7
x39_1 vrefh net-_x39_1-pad2_ d39_0 d39_1 d39_2 d39_3 d39_4 d39_5 d39_6 vdd net-_x39_1-pad11_ s7bit_DAC
x39_2 net-_x39_1-pad2_ vrefl d39_0 d39_1 d39_2 d39_3 d39_4 d39_5 d39_6 vdd net-_x39_2-pad11_ s7bit_DAC
x39_3 d39_7 vdd net-_x39_1-pad11_ net-_x39_2-pad11_ m_7 switch

Vd39_0 d39_0 0 PWL (0.0 0.0 9.999999960041972e-13 0.0 9.99999993922529e-09 0.0 1.0001000028125873e-08 1.7999999523162842 1.999999987845058e-08 1.7999999523162842 2.0000999967351163e-08 1.7999999523162842 2.999999892949745e-08 1.7999999523162842 3.000100079475487e-08 1.7999999523162842 3.999999975690116e-08 1.7999999523162842 4.000100162215858e-08 1.7999999523162842 5.000000058430487e-08 1.7999999523162842 )
Vd39_1 d39_1 0 PWL (0.0 0.0 9.999999960041972e-13 0.0 9.99999993922529e-09 0.0 1.0001000028125873e-08 1.7999999523162842 1.999999987845058e-08 1.7999999523162842 2.0000999967351163e-08 1.7999999523162842 2.999999892949745e-08 1.7999999523162842 3.000100079475487e-08 1.7999999523162842 3.999999975690116e-08 1.7999999523162842 4.000100162215858e-08 1.7999999523162842 5.000000058430487e-08 1.7999999523162842 )
Vd39_2 d39_2 0 PWL (0.0 0.0 9.999999960041972e-13 0.0 9.99999993922529e-09 0.0 1.0001000028125873e-08 1.7999999523162842 1.999999987845058e-08 1.7999999523162842 2.0000999967351163e-08 1.7999999523162842 2.999999892949745e-08 1.7999999523162842 3.000100079475487e-08 1.7999999523162842 3.999999975690116e-08 1.7999999523162842 4.000100162215858e-08 1.7999999523162842 5.000000058430487e-08 1.7999999523162842 )
Vd39_3 d39_3 0 PWL (0.0 0.0 9.999999960041972e-13 0.0 9.99999993922529e-09 0.0 1.0001000028125873e-08 1.7999999523162842 1.999999987845058e-08 1.7999999523162842 2.0000999967351163e-08 1.7999999523162842 2.999999892949745e-08 1.7999999523162842 3.000100079475487e-08 1.7999999523162842 3.999999975690116e-08 1.7999999523162842 4.000100162215858e-08 1.7999999523162842 5.000000058430487e-08 1.7999999523162842 )
Vd39_4 d39_4 0 PWL (0.0 0.0 9.999999960041972e-13 0.0 9.99999993922529e-09 0.0 1.0001000028125873e-08 1.7999999523162842 1.999999987845058e-08 1.7999999523162842 2.0000999967351163e-08 1.7999999523162842 2.999999892949745e-08 1.7999999523162842 3.000100079475487e-08 1.7999999523162842 3.999999975690116e-08 1.7999999523162842 4.000100162215858e-08 1.7999999523162842 5.000000058430487e-08 1.7999999523162842 )
Vd39_5 d39_5 0 PWL (0.0 0.0 9.999999960041972e-13 0.0 9.99999993922529e-09 0.0 1.0001000028125873e-08 1.7999999523162842 1.999999987845058e-08 1.7999999523162842 2.0000999967351163e-08 1.7999999523162842 2.999999892949745e-08 1.7999999523162842 3.000100079475487e-08 1.7999999523162842 3.999999975690116e-08 1.7999999523162842 4.000100162215858e-08 1.7999999523162842 5.000000058430487e-08 1.7999999523162842 )
Vd39_6 d39_6 0 PWL (0.0 0.0 9.999999960041972e-13 0.0 9.99999993922529e-09 0.0 1.0001000028125873e-08 0.0 1.999999987845058e-08 0.0 2.0000999967351163e-08 1.7999999523162842 2.999999892949745e-08 1.7999999523162842 3.000100079475487e-08 0.0 3.999999975690116e-08 0.0 4.000100162215858e-08 1.7999999523162842 5.000000058430487e-08 1.7999999523162842 )
Vd39_7 d39_7 0 PWL (0.0 0.0 9.999999960041972e-13 0.0 9.99999993922529e-09 0.0 1.0001000028125873e-08 0.0 1.999999987845058e-08 0.0 2.0000999967351163e-08 0.0 2.999999892949745e-08 0.0 3.000100079475487e-08 1.7999999523162842 3.999999975690116e-08 1.7999999523162842 4.000100162215858e-08 1.7999999523162842 5.000000058430487e-08 1.7999999523162842 )

    * DAC for operand fed to m_8
x44_1 vrefh net-_x44_1-pad2_ d44_0 d44_1 d44_2 d44_3 d44_4 d44_5 d44_6 vdd net-_x44_1-pad11_ s7bit_DAC
x44_2 net-_x44_1-pad2_ vrefl d44_0 d44_1 d44_2 d44_3 d44_4 d44_5 d44_6 vdd net-_x44_2-pad11_ s7bit_DAC
x44_3 d44_7 vdd net-_x44_1-pad11_ net-_x44_2-pad11_ m_8 switch

Vd44_0 d44_0 0 PWL (0.0 0.0 9.999999960041972e-13 0.0 9.99999993922529e-09 0.0 1.0001000028125873e-08 1.7999999523162842 1.999999987845058e-08 1.7999999523162842 2.0000999967351163e-08 1.7999999523162842 2.999999892949745e-08 1.7999999523162842 3.000100079475487e-08 1.7999999523162842 3.999999975690116e-08 1.7999999523162842 4.000100162215858e-08 1.7999999523162842 5.000000058430487e-08 1.7999999523162842 )
Vd44_1 d44_1 0 PWL (0.0 0.0 9.999999960041972e-13 0.0 9.99999993922529e-09 0.0 1.0001000028125873e-08 1.7999999523162842 1.999999987845058e-08 1.7999999523162842 2.0000999967351163e-08 1.7999999523162842 2.999999892949745e-08 1.7999999523162842 3.000100079475487e-08 1.7999999523162842 3.999999975690116e-08 1.7999999523162842 4.000100162215858e-08 1.7999999523162842 5.000000058430487e-08 1.7999999523162842 )
Vd44_2 d44_2 0 PWL (0.0 0.0 9.999999960041972e-13 0.0 9.99999993922529e-09 0.0 1.0001000028125873e-08 1.7999999523162842 1.999999987845058e-08 1.7999999523162842 2.0000999967351163e-08 1.7999999523162842 2.999999892949745e-08 1.7999999523162842 3.000100079475487e-08 1.7999999523162842 3.999999975690116e-08 1.7999999523162842 4.000100162215858e-08 1.7999999523162842 5.000000058430487e-08 1.7999999523162842 )
Vd44_3 d44_3 0 PWL (0.0 0.0 9.999999960041972e-13 0.0 9.99999993922529e-09 0.0 1.0001000028125873e-08 1.7999999523162842 1.999999987845058e-08 1.7999999523162842 2.0000999967351163e-08 1.7999999523162842 2.999999892949745e-08 1.7999999523162842 3.000100079475487e-08 1.7999999523162842 3.999999975690116e-08 1.7999999523162842 4.000100162215858e-08 1.7999999523162842 5.000000058430487e-08 1.7999999523162842 )
Vd44_4 d44_4 0 PWL (0.0 0.0 9.999999960041972e-13 0.0 9.99999993922529e-09 0.0 1.0001000028125873e-08 1.7999999523162842 1.999999987845058e-08 1.7999999523162842 2.0000999967351163e-08 1.7999999523162842 2.999999892949745e-08 1.7999999523162842 3.000100079475487e-08 1.7999999523162842 3.999999975690116e-08 1.7999999523162842 4.000100162215858e-08 1.7999999523162842 5.000000058430487e-08 1.7999999523162842 )
Vd44_5 d44_5 0 PWL (0.0 0.0 9.999999960041972e-13 0.0 9.99999993922529e-09 0.0 1.0001000028125873e-08 1.7999999523162842 1.999999987845058e-08 1.7999999523162842 2.0000999967351163e-08 1.7999999523162842 2.999999892949745e-08 1.7999999523162842 3.000100079475487e-08 1.7999999523162842 3.999999975690116e-08 1.7999999523162842 4.000100162215858e-08 1.7999999523162842 5.000000058430487e-08 1.7999999523162842 )
Vd44_6 d44_6 0 PWL (0.0 0.0 9.999999960041972e-13 0.0 9.99999993922529e-09 0.0 1.0001000028125873e-08 0.0 1.999999987845058e-08 0.0 2.0000999967351163e-08 1.7999999523162842 2.999999892949745e-08 1.7999999523162842 3.000100079475487e-08 0.0 3.999999975690116e-08 0.0 4.000100162215858e-08 1.7999999523162842 5.000000058430487e-08 1.7999999523162842 )
Vd44_7 d44_7 0 PWL (0.0 0.0 9.999999960041972e-13 0.0 9.99999993922529e-09 0.0 1.0001000028125873e-08 0.0 1.999999987845058e-08 0.0 2.0000999967351163e-08 0.0 2.999999892949745e-08 0.0 3.000100079475487e-08 1.7999999523162842 3.999999975690116e-08 1.7999999523162842 4.000100162215858e-08 1.7999999523162842 5.000000058430487e-08 1.7999999523162842 )

    * DAC for operand fed to m_9
x49_1 vrefh net-_x49_1-pad2_ d49_0 d49_1 d49_2 d49_3 d49_4 d49_5 d49_6 vdd net-_x49_1-pad11_ s7bit_DAC
x49_2 net-_x49_1-pad2_ vrefl d49_0 d49_1 d49_2 d49_3 d49_4 d49_5 d49_6 vdd net-_x49_2-pad11_ s7bit_DAC
x49_3 d49_7 vdd net-_x49_1-pad11_ net-_x49_2-pad11_ m_9 switch

Vd49_0 d49_0 0 PWL (0.0 0.0 9.999999960041972e-13 0.0 9.99999993922529e-09 0.0 1.0001000028125873e-08 1.7999999523162842 1.999999987845058e-08 1.7999999523162842 2.0000999967351163e-08 1.7999999523162842 2.999999892949745e-08 1.7999999523162842 3.000100079475487e-08 1.7999999523162842 3.999999975690116e-08 1.7999999523162842 4.000100162215858e-08 1.7999999523162842 5.000000058430487e-08 1.7999999523162842 )
Vd49_1 d49_1 0 PWL (0.0 0.0 9.999999960041972e-13 0.0 9.99999993922529e-09 0.0 1.0001000028125873e-08 1.7999999523162842 1.999999987845058e-08 1.7999999523162842 2.0000999967351163e-08 1.7999999523162842 2.999999892949745e-08 1.7999999523162842 3.000100079475487e-08 1.7999999523162842 3.999999975690116e-08 1.7999999523162842 4.000100162215858e-08 1.7999999523162842 5.000000058430487e-08 1.7999999523162842 )
Vd49_2 d49_2 0 PWL (0.0 0.0 9.999999960041972e-13 0.0 9.99999993922529e-09 0.0 1.0001000028125873e-08 1.7999999523162842 1.999999987845058e-08 1.7999999523162842 2.0000999967351163e-08 1.7999999523162842 2.999999892949745e-08 1.7999999523162842 3.000100079475487e-08 1.7999999523162842 3.999999975690116e-08 1.7999999523162842 4.000100162215858e-08 1.7999999523162842 5.000000058430487e-08 1.7999999523162842 )
Vd49_3 d49_3 0 PWL (0.0 0.0 9.999999960041972e-13 0.0 9.99999993922529e-09 0.0 1.0001000028125873e-08 1.7999999523162842 1.999999987845058e-08 1.7999999523162842 2.0000999967351163e-08 1.7999999523162842 2.999999892949745e-08 1.7999999523162842 3.000100079475487e-08 1.7999999523162842 3.999999975690116e-08 1.7999999523162842 4.000100162215858e-08 1.7999999523162842 5.000000058430487e-08 1.7999999523162842 )
Vd49_4 d49_4 0 PWL (0.0 0.0 9.999999960041972e-13 0.0 9.99999993922529e-09 0.0 1.0001000028125873e-08 1.7999999523162842 1.999999987845058e-08 1.7999999523162842 2.0000999967351163e-08 1.7999999523162842 2.999999892949745e-08 1.7999999523162842 3.000100079475487e-08 1.7999999523162842 3.999999975690116e-08 1.7999999523162842 4.000100162215858e-08 1.7999999523162842 5.000000058430487e-08 1.7999999523162842 )
Vd49_5 d49_5 0 PWL (0.0 0.0 9.999999960041972e-13 0.0 9.99999993922529e-09 0.0 1.0001000028125873e-08 1.7999999523162842 1.999999987845058e-08 1.7999999523162842 2.0000999967351163e-08 1.7999999523162842 2.999999892949745e-08 1.7999999523162842 3.000100079475487e-08 1.7999999523162842 3.999999975690116e-08 1.7999999523162842 4.000100162215858e-08 1.7999999523162842 5.000000058430487e-08 1.7999999523162842 )
Vd49_6 d49_6 0 PWL (0.0 0.0 9.999999960041972e-13 0.0 9.99999993922529e-09 0.0 1.0001000028125873e-08 0.0 1.999999987845058e-08 0.0 2.0000999967351163e-08 1.7999999523162842 2.999999892949745e-08 1.7999999523162842 3.000100079475487e-08 0.0 3.999999975690116e-08 0.0 4.000100162215858e-08 1.7999999523162842 5.000000058430487e-08 1.7999999523162842 )
Vd49_7 d49_7 0 PWL (0.0 0.0 9.999999960041972e-13 0.0 9.99999993922529e-09 0.0 1.0001000028125873e-08 0.0 1.999999987845058e-08 0.0 2.0000999967351163e-08 0.0 2.999999892949745e-08 0.0 3.000100079475487e-08 1.7999999523162842 3.999999975690116e-08 1.7999999523162842 4.000100162215858e-08 1.7999999523162842 5.000000058430487e-08 1.7999999523162842 )

    * DAC for operand fed to m_10
x54_1 vrefh net-_x54_1-pad2_ d54_0 d54_1 d54_2 d54_3 d54_4 d54_5 d54_6 vdd net-_x54_1-pad11_ s7bit_DAC
x54_2 net-_x54_1-pad2_ vrefl d54_0 d54_1 d54_2 d54_3 d54_4 d54_5 d54_6 vdd net-_x54_2-pad11_ s7bit_DAC
x54_3 d54_7 vdd net-_x54_1-pad11_ net-_x54_2-pad11_ m_10 switch

Vd54_0 d54_0 0 PWL (0.0 0.0 9.999999960041972e-13 0.0 9.99999993922529e-09 0.0 1.0001000028125873e-08 1.7999999523162842 1.999999987845058e-08 1.7999999523162842 2.0000999967351163e-08 1.7999999523162842 2.999999892949745e-08 1.7999999523162842 3.000100079475487e-08 1.7999999523162842 3.999999975690116e-08 1.7999999523162842 4.000100162215858e-08 1.7999999523162842 5.000000058430487e-08 1.7999999523162842 )
Vd54_1 d54_1 0 PWL (0.0 0.0 9.999999960041972e-13 0.0 9.99999993922529e-09 0.0 1.0001000028125873e-08 1.7999999523162842 1.999999987845058e-08 1.7999999523162842 2.0000999967351163e-08 1.7999999523162842 2.999999892949745e-08 1.7999999523162842 3.000100079475487e-08 1.7999999523162842 3.999999975690116e-08 1.7999999523162842 4.000100162215858e-08 1.7999999523162842 5.000000058430487e-08 1.7999999523162842 )
Vd54_2 d54_2 0 PWL (0.0 0.0 9.999999960041972e-13 0.0 9.99999993922529e-09 0.0 1.0001000028125873e-08 1.7999999523162842 1.999999987845058e-08 1.7999999523162842 2.0000999967351163e-08 1.7999999523162842 2.999999892949745e-08 1.7999999523162842 3.000100079475487e-08 1.7999999523162842 3.999999975690116e-08 1.7999999523162842 4.000100162215858e-08 1.7999999523162842 5.000000058430487e-08 1.7999999523162842 )
Vd54_3 d54_3 0 PWL (0.0 0.0 9.999999960041972e-13 0.0 9.99999993922529e-09 0.0 1.0001000028125873e-08 1.7999999523162842 1.999999987845058e-08 1.7999999523162842 2.0000999967351163e-08 1.7999999523162842 2.999999892949745e-08 1.7999999523162842 3.000100079475487e-08 1.7999999523162842 3.999999975690116e-08 1.7999999523162842 4.000100162215858e-08 1.7999999523162842 5.000000058430487e-08 1.7999999523162842 )
Vd54_4 d54_4 0 PWL (0.0 0.0 9.999999960041972e-13 0.0 9.99999993922529e-09 0.0 1.0001000028125873e-08 1.7999999523162842 1.999999987845058e-08 1.7999999523162842 2.0000999967351163e-08 1.7999999523162842 2.999999892949745e-08 1.7999999523162842 3.000100079475487e-08 1.7999999523162842 3.999999975690116e-08 1.7999999523162842 4.000100162215858e-08 1.7999999523162842 5.000000058430487e-08 1.7999999523162842 )
Vd54_5 d54_5 0 PWL (0.0 0.0 9.999999960041972e-13 0.0 9.99999993922529e-09 0.0 1.0001000028125873e-08 1.7999999523162842 1.999999987845058e-08 1.7999999523162842 2.0000999967351163e-08 1.7999999523162842 2.999999892949745e-08 1.7999999523162842 3.000100079475487e-08 1.7999999523162842 3.999999975690116e-08 1.7999999523162842 4.000100162215858e-08 1.7999999523162842 5.000000058430487e-08 1.7999999523162842 )
Vd54_6 d54_6 0 PWL (0.0 0.0 9.999999960041972e-13 0.0 9.99999993922529e-09 0.0 1.0001000028125873e-08 0.0 1.999999987845058e-08 0.0 2.0000999967351163e-08 1.7999999523162842 2.999999892949745e-08 1.7999999523162842 3.000100079475487e-08 0.0 3.999999975690116e-08 0.0 4.000100162215858e-08 1.7999999523162842 5.000000058430487e-08 1.7999999523162842 )
Vd54_7 d54_7 0 PWL (0.0 0.0 9.999999960041972e-13 0.0 9.99999993922529e-09 0.0 1.0001000028125873e-08 0.0 1.999999987845058e-08 0.0 2.0000999967351163e-08 0.0 2.999999892949745e-08 0.0 3.000100079475487e-08 1.7999999523162842 3.999999975690116e-08 1.7999999523162842 4.000100162215858e-08 1.7999999523162842 5.000000058430487e-08 1.7999999523162842 )

    * DAC for operand fed to m_11
x59_1 vrefh net-_x59_1-pad2_ d59_0 d59_1 d59_2 d59_3 d59_4 d59_5 d59_6 vdd net-_x59_1-pad11_ s7bit_DAC
x59_2 net-_x59_1-pad2_ vrefl d59_0 d59_1 d59_2 d59_3 d59_4 d59_5 d59_6 vdd net-_x59_2-pad11_ s7bit_DAC
x59_3 d59_7 vdd net-_x59_1-pad11_ net-_x59_2-pad11_ m_11 switch

Vd59_0 d59_0 0 PWL (0.0 0.0 9.999999960041972e-13 0.0 9.99999993922529e-09 0.0 1.0001000028125873e-08 1.7999999523162842 1.999999987845058e-08 1.7999999523162842 2.0000999967351163e-08 1.7999999523162842 2.999999892949745e-08 1.7999999523162842 3.000100079475487e-08 1.7999999523162842 3.999999975690116e-08 1.7999999523162842 4.000100162215858e-08 1.7999999523162842 5.000000058430487e-08 1.7999999523162842 )
Vd59_1 d59_1 0 PWL (0.0 0.0 9.999999960041972e-13 0.0 9.99999993922529e-09 0.0 1.0001000028125873e-08 1.7999999523162842 1.999999987845058e-08 1.7999999523162842 2.0000999967351163e-08 1.7999999523162842 2.999999892949745e-08 1.7999999523162842 3.000100079475487e-08 1.7999999523162842 3.999999975690116e-08 1.7999999523162842 4.000100162215858e-08 1.7999999523162842 5.000000058430487e-08 1.7999999523162842 )
Vd59_2 d59_2 0 PWL (0.0 0.0 9.999999960041972e-13 0.0 9.99999993922529e-09 0.0 1.0001000028125873e-08 1.7999999523162842 1.999999987845058e-08 1.7999999523162842 2.0000999967351163e-08 1.7999999523162842 2.999999892949745e-08 1.7999999523162842 3.000100079475487e-08 1.7999999523162842 3.999999975690116e-08 1.7999999523162842 4.000100162215858e-08 1.7999999523162842 5.000000058430487e-08 1.7999999523162842 )
Vd59_3 d59_3 0 PWL (0.0 0.0 9.999999960041972e-13 0.0 9.99999993922529e-09 0.0 1.0001000028125873e-08 1.7999999523162842 1.999999987845058e-08 1.7999999523162842 2.0000999967351163e-08 1.7999999523162842 2.999999892949745e-08 1.7999999523162842 3.000100079475487e-08 1.7999999523162842 3.999999975690116e-08 1.7999999523162842 4.000100162215858e-08 1.7999999523162842 5.000000058430487e-08 1.7999999523162842 )
Vd59_4 d59_4 0 PWL (0.0 0.0 9.999999960041972e-13 0.0 9.99999993922529e-09 0.0 1.0001000028125873e-08 1.7999999523162842 1.999999987845058e-08 1.7999999523162842 2.0000999967351163e-08 1.7999999523162842 2.999999892949745e-08 1.7999999523162842 3.000100079475487e-08 1.7999999523162842 3.999999975690116e-08 1.7999999523162842 4.000100162215858e-08 1.7999999523162842 5.000000058430487e-08 1.7999999523162842 )
Vd59_5 d59_5 0 PWL (0.0 0.0 9.999999960041972e-13 0.0 9.99999993922529e-09 0.0 1.0001000028125873e-08 1.7999999523162842 1.999999987845058e-08 1.7999999523162842 2.0000999967351163e-08 1.7999999523162842 2.999999892949745e-08 1.7999999523162842 3.000100079475487e-08 1.7999999523162842 3.999999975690116e-08 1.7999999523162842 4.000100162215858e-08 1.7999999523162842 5.000000058430487e-08 1.7999999523162842 )
Vd59_6 d59_6 0 PWL (0.0 0.0 9.999999960041972e-13 0.0 9.99999993922529e-09 0.0 1.0001000028125873e-08 0.0 1.999999987845058e-08 0.0 2.0000999967351163e-08 1.7999999523162842 2.999999892949745e-08 1.7999999523162842 3.000100079475487e-08 0.0 3.999999975690116e-08 0.0 4.000100162215858e-08 1.7999999523162842 5.000000058430487e-08 1.7999999523162842 )
Vd59_7 d59_7 0 PWL (0.0 0.0 9.999999960041972e-13 0.0 9.99999993922529e-09 0.0 1.0001000028125873e-08 0.0 1.999999987845058e-08 0.0 2.0000999967351163e-08 0.0 2.999999892949745e-08 0.0 3.000100079475487e-08 1.7999999523162842 3.999999975690116e-08 1.7999999523162842 4.000100162215858e-08 1.7999999523162842 5.000000058430487e-08 1.7999999523162842 )

    * DAC for operand fed to m_12
x64_1 vrefh net-_x64_1-pad2_ d64_0 d64_1 d64_2 d64_3 d64_4 d64_5 d64_6 vdd net-_x64_1-pad11_ s7bit_DAC
x64_2 net-_x64_1-pad2_ vrefl d64_0 d64_1 d64_2 d64_3 d64_4 d64_5 d64_6 vdd net-_x64_2-pad11_ s7bit_DAC
x64_3 d64_7 vdd net-_x64_1-pad11_ net-_x64_2-pad11_ m_12 switch

Vd64_0 d64_0 0 PWL (0.0 0.0 9.999999960041972e-13 0.0 9.99999993922529e-09 0.0 1.0001000028125873e-08 1.7999999523162842 1.999999987845058e-08 1.7999999523162842 2.0000999967351163e-08 1.7999999523162842 2.999999892949745e-08 1.7999999523162842 3.000100079475487e-08 1.7999999523162842 3.999999975690116e-08 1.7999999523162842 4.000100162215858e-08 1.7999999523162842 5.000000058430487e-08 1.7999999523162842 )
Vd64_1 d64_1 0 PWL (0.0 0.0 9.999999960041972e-13 0.0 9.99999993922529e-09 0.0 1.0001000028125873e-08 1.7999999523162842 1.999999987845058e-08 1.7999999523162842 2.0000999967351163e-08 1.7999999523162842 2.999999892949745e-08 1.7999999523162842 3.000100079475487e-08 1.7999999523162842 3.999999975690116e-08 1.7999999523162842 4.000100162215858e-08 1.7999999523162842 5.000000058430487e-08 1.7999999523162842 )
Vd64_2 d64_2 0 PWL (0.0 0.0 9.999999960041972e-13 0.0 9.99999993922529e-09 0.0 1.0001000028125873e-08 1.7999999523162842 1.999999987845058e-08 1.7999999523162842 2.0000999967351163e-08 1.7999999523162842 2.999999892949745e-08 1.7999999523162842 3.000100079475487e-08 1.7999999523162842 3.999999975690116e-08 1.7999999523162842 4.000100162215858e-08 1.7999999523162842 5.000000058430487e-08 1.7999999523162842 )
Vd64_3 d64_3 0 PWL (0.0 0.0 9.999999960041972e-13 0.0 9.99999993922529e-09 0.0 1.0001000028125873e-08 1.7999999523162842 1.999999987845058e-08 1.7999999523162842 2.0000999967351163e-08 1.7999999523162842 2.999999892949745e-08 1.7999999523162842 3.000100079475487e-08 1.7999999523162842 3.999999975690116e-08 1.7999999523162842 4.000100162215858e-08 1.7999999523162842 5.000000058430487e-08 1.7999999523162842 )
Vd64_4 d64_4 0 PWL (0.0 0.0 9.999999960041972e-13 0.0 9.99999993922529e-09 0.0 1.0001000028125873e-08 1.7999999523162842 1.999999987845058e-08 1.7999999523162842 2.0000999967351163e-08 1.7999999523162842 2.999999892949745e-08 1.7999999523162842 3.000100079475487e-08 1.7999999523162842 3.999999975690116e-08 1.7999999523162842 4.000100162215858e-08 1.7999999523162842 5.000000058430487e-08 1.7999999523162842 )
Vd64_5 d64_5 0 PWL (0.0 0.0 9.999999960041972e-13 0.0 9.99999993922529e-09 0.0 1.0001000028125873e-08 1.7999999523162842 1.999999987845058e-08 1.7999999523162842 2.0000999967351163e-08 1.7999999523162842 2.999999892949745e-08 1.7999999523162842 3.000100079475487e-08 1.7999999523162842 3.999999975690116e-08 1.7999999523162842 4.000100162215858e-08 1.7999999523162842 5.000000058430487e-08 1.7999999523162842 )
Vd64_6 d64_6 0 PWL (0.0 0.0 9.999999960041972e-13 0.0 9.99999993922529e-09 0.0 1.0001000028125873e-08 0.0 1.999999987845058e-08 0.0 2.0000999967351163e-08 1.7999999523162842 2.999999892949745e-08 1.7999999523162842 3.000100079475487e-08 0.0 3.999999975690116e-08 0.0 4.000100162215858e-08 1.7999999523162842 5.000000058430487e-08 1.7999999523162842 )
Vd64_7 d64_7 0 PWL (0.0 0.0 9.999999960041972e-13 0.0 9.99999993922529e-09 0.0 1.0001000028125873e-08 0.0 1.999999987845058e-08 0.0 2.0000999967351163e-08 0.0 2.999999892949745e-08 0.0 3.000100079475487e-08 1.7999999523162842 3.999999975690116e-08 1.7999999523162842 4.000100162215858e-08 1.7999999523162842 5.000000058430487e-08 1.7999999523162842 )

    * DAC for operand fed to m_13
x69_1 vrefh net-_x69_1-pad2_ d69_0 d69_1 d69_2 d69_3 d69_4 d69_5 d69_6 vdd net-_x69_1-pad11_ s7bit_DAC
x69_2 net-_x69_1-pad2_ vrefl d69_0 d69_1 d69_2 d69_3 d69_4 d69_5 d69_6 vdd net-_x69_2-pad11_ s7bit_DAC
x69_3 d69_7 vdd net-_x69_1-pad11_ net-_x69_2-pad11_ m_13 switch

Vd69_0 d69_0 0 PWL (0.0 0.0 9.999999960041972e-13 0.0 9.99999993922529e-09 0.0 1.0001000028125873e-08 1.7999999523162842 1.999999987845058e-08 1.7999999523162842 2.0000999967351163e-08 1.7999999523162842 2.999999892949745e-08 1.7999999523162842 3.000100079475487e-08 1.7999999523162842 3.999999975690116e-08 1.7999999523162842 4.000100162215858e-08 1.7999999523162842 5.000000058430487e-08 1.7999999523162842 )
Vd69_1 d69_1 0 PWL (0.0 0.0 9.999999960041972e-13 0.0 9.99999993922529e-09 0.0 1.0001000028125873e-08 1.7999999523162842 1.999999987845058e-08 1.7999999523162842 2.0000999967351163e-08 1.7999999523162842 2.999999892949745e-08 1.7999999523162842 3.000100079475487e-08 1.7999999523162842 3.999999975690116e-08 1.7999999523162842 4.000100162215858e-08 1.7999999523162842 5.000000058430487e-08 1.7999999523162842 )
Vd69_2 d69_2 0 PWL (0.0 0.0 9.999999960041972e-13 0.0 9.99999993922529e-09 0.0 1.0001000028125873e-08 1.7999999523162842 1.999999987845058e-08 1.7999999523162842 2.0000999967351163e-08 1.7999999523162842 2.999999892949745e-08 1.7999999523162842 3.000100079475487e-08 1.7999999523162842 3.999999975690116e-08 1.7999999523162842 4.000100162215858e-08 1.7999999523162842 5.000000058430487e-08 1.7999999523162842 )
Vd69_3 d69_3 0 PWL (0.0 0.0 9.999999960041972e-13 0.0 9.99999993922529e-09 0.0 1.0001000028125873e-08 1.7999999523162842 1.999999987845058e-08 1.7999999523162842 2.0000999967351163e-08 1.7999999523162842 2.999999892949745e-08 1.7999999523162842 3.000100079475487e-08 1.7999999523162842 3.999999975690116e-08 1.7999999523162842 4.000100162215858e-08 1.7999999523162842 5.000000058430487e-08 1.7999999523162842 )
Vd69_4 d69_4 0 PWL (0.0 0.0 9.999999960041972e-13 0.0 9.99999993922529e-09 0.0 1.0001000028125873e-08 1.7999999523162842 1.999999987845058e-08 1.7999999523162842 2.0000999967351163e-08 1.7999999523162842 2.999999892949745e-08 1.7999999523162842 3.000100079475487e-08 1.7999999523162842 3.999999975690116e-08 1.7999999523162842 4.000100162215858e-08 1.7999999523162842 5.000000058430487e-08 1.7999999523162842 )
Vd69_5 d69_5 0 PWL (0.0 0.0 9.999999960041972e-13 0.0 9.99999993922529e-09 0.0 1.0001000028125873e-08 1.7999999523162842 1.999999987845058e-08 1.7999999523162842 2.0000999967351163e-08 1.7999999523162842 2.999999892949745e-08 1.7999999523162842 3.000100079475487e-08 1.7999999523162842 3.999999975690116e-08 1.7999999523162842 4.000100162215858e-08 1.7999999523162842 5.000000058430487e-08 1.7999999523162842 )
Vd69_6 d69_6 0 PWL (0.0 0.0 9.999999960041972e-13 0.0 9.99999993922529e-09 0.0 1.0001000028125873e-08 0.0 1.999999987845058e-08 0.0 2.0000999967351163e-08 1.7999999523162842 2.999999892949745e-08 1.7999999523162842 3.000100079475487e-08 0.0 3.999999975690116e-08 0.0 4.000100162215858e-08 1.7999999523162842 5.000000058430487e-08 1.7999999523162842 )
Vd69_7 d69_7 0 PWL (0.0 0.0 9.999999960041972e-13 0.0 9.99999993922529e-09 0.0 1.0001000028125873e-08 0.0 1.999999987845058e-08 0.0 2.0000999967351163e-08 0.0 2.999999892949745e-08 0.0 3.000100079475487e-08 1.7999999523162842 3.999999975690116e-08 1.7999999523162842 4.000100162215858e-08 1.7999999523162842 5.000000058430487e-08 1.7999999523162842 )

    * DAC for operand fed to m_14
x74_1 vrefh net-_x74_1-pad2_ d74_0 d74_1 d74_2 d74_3 d74_4 d74_5 d74_6 vdd net-_x74_1-pad11_ s7bit_DAC
x74_2 net-_x74_1-pad2_ vrefl d74_0 d74_1 d74_2 d74_3 d74_4 d74_5 d74_6 vdd net-_x74_2-pad11_ s7bit_DAC
x74_3 d74_7 vdd net-_x74_1-pad11_ net-_x74_2-pad11_ m_14 switch

Vd74_0 d74_0 0 PWL (0.0 0.0 9.999999960041972e-13 0.0 9.99999993922529e-09 0.0 1.0001000028125873e-08 1.7999999523162842 1.999999987845058e-08 1.7999999523162842 2.0000999967351163e-08 1.7999999523162842 2.999999892949745e-08 1.7999999523162842 3.000100079475487e-08 1.7999999523162842 3.999999975690116e-08 1.7999999523162842 4.000100162215858e-08 1.7999999523162842 5.000000058430487e-08 1.7999999523162842 )
Vd74_1 d74_1 0 PWL (0.0 0.0 9.999999960041972e-13 0.0 9.99999993922529e-09 0.0 1.0001000028125873e-08 1.7999999523162842 1.999999987845058e-08 1.7999999523162842 2.0000999967351163e-08 1.7999999523162842 2.999999892949745e-08 1.7999999523162842 3.000100079475487e-08 1.7999999523162842 3.999999975690116e-08 1.7999999523162842 4.000100162215858e-08 1.7999999523162842 5.000000058430487e-08 1.7999999523162842 )
Vd74_2 d74_2 0 PWL (0.0 0.0 9.999999960041972e-13 0.0 9.99999993922529e-09 0.0 1.0001000028125873e-08 1.7999999523162842 1.999999987845058e-08 1.7999999523162842 2.0000999967351163e-08 1.7999999523162842 2.999999892949745e-08 1.7999999523162842 3.000100079475487e-08 1.7999999523162842 3.999999975690116e-08 1.7999999523162842 4.000100162215858e-08 1.7999999523162842 5.000000058430487e-08 1.7999999523162842 )
Vd74_3 d74_3 0 PWL (0.0 0.0 9.999999960041972e-13 0.0 9.99999993922529e-09 0.0 1.0001000028125873e-08 1.7999999523162842 1.999999987845058e-08 1.7999999523162842 2.0000999967351163e-08 1.7999999523162842 2.999999892949745e-08 1.7999999523162842 3.000100079475487e-08 1.7999999523162842 3.999999975690116e-08 1.7999999523162842 4.000100162215858e-08 1.7999999523162842 5.000000058430487e-08 1.7999999523162842 )
Vd74_4 d74_4 0 PWL (0.0 0.0 9.999999960041972e-13 0.0 9.99999993922529e-09 0.0 1.0001000028125873e-08 1.7999999523162842 1.999999987845058e-08 1.7999999523162842 2.0000999967351163e-08 1.7999999523162842 2.999999892949745e-08 1.7999999523162842 3.000100079475487e-08 1.7999999523162842 3.999999975690116e-08 1.7999999523162842 4.000100162215858e-08 1.7999999523162842 5.000000058430487e-08 1.7999999523162842 )
Vd74_5 d74_5 0 PWL (0.0 0.0 9.999999960041972e-13 0.0 9.99999993922529e-09 0.0 1.0001000028125873e-08 1.7999999523162842 1.999999987845058e-08 1.7999999523162842 2.0000999967351163e-08 1.7999999523162842 2.999999892949745e-08 1.7999999523162842 3.000100079475487e-08 1.7999999523162842 3.999999975690116e-08 1.7999999523162842 4.000100162215858e-08 1.7999999523162842 5.000000058430487e-08 1.7999999523162842 )
Vd74_6 d74_6 0 PWL (0.0 0.0 9.999999960041972e-13 0.0 9.99999993922529e-09 0.0 1.0001000028125873e-08 0.0 1.999999987845058e-08 0.0 2.0000999967351163e-08 1.7999999523162842 2.999999892949745e-08 1.7999999523162842 3.000100079475487e-08 0.0 3.999999975690116e-08 0.0 4.000100162215858e-08 1.7999999523162842 5.000000058430487e-08 1.7999999523162842 )
Vd74_7 d74_7 0 PWL (0.0 0.0 9.999999960041972e-13 0.0 9.99999993922529e-09 0.0 1.0001000028125873e-08 0.0 1.999999987845058e-08 0.0 2.0000999967351163e-08 0.0 2.999999892949745e-08 0.0 3.000100079475487e-08 1.7999999523162842 3.999999975690116e-08 1.7999999523162842 4.000100162215858e-08 1.7999999523162842 5.000000058430487e-08 1.7999999523162842 )
.include ./dac_model/8bit_DAC/switch.sub
.include ./dac_model/8bit_DAC/7bit_DAC.sub
Vdd vdd 0 3.3
Vrefh vrefh 0 3.3
Vrefl vrefl 0 0

.tran 0 5.000000058430487e-08 200

.photonic
splitter1to2_0 n_0_0 ni_1_0_1 ni_1_0_2
wg_1 ni_1_0_1 ni_1_0_3 l=0
wg_2 ni_1_0_2 n_1_1 l=0
modp_3 ni_1_0_3 n_1_0 m_0 debug coeff1=0.001 act_l=0.0002
splitter1to2_5 n_1_0 ni_2_0_1 ni_2_0_2
wg_6 ni_2_0_1 ni_2_0_3 l=0
wg_7 ni_2_0_2 n_2_1 l=0
modp_8 ni_2_0_3 n_2_0 m_1 debug coeff1=0.001 act_l=0.0002
splitter1to2_10 n_1_1 ni_2_1_1 ni_2_1_2
wg_11 ni_2_1_1 ni_2_1_3 l=0
wg_12 ni_2_1_2 n_2_3 l=0
modp_13 ni_2_1_3 n_2_2 m_2 debug coeff1=0.001 act_l=0.0002
splitter1to2_15 n_2_0 ni_3_0_1 ni_3_0_2
wg_16 ni_3_0_1 ni_3_0_3 l=0
wg_17 ni_3_0_2 n_3_1 l=0
modp_18 ni_3_0_3 n_3_0 m_3 debug coeff1=0.001 act_l=0.0002
splitter1to2_20 n_2_1 ni_3_1_1 ni_3_1_2
wg_21 ni_3_1_1 ni_3_1_3 l=0
wg_22 ni_3_1_2 n_3_3 l=0
modp_23 ni_3_1_3 n_3_2 m_4 debug coeff1=0.001 act_l=0.0002
splitter1to2_25 n_2_2 ni_3_2_1 ni_3_2_2
wg_26 ni_3_2_1 ni_3_2_3 l=0
wg_27 ni_3_2_2 n_3_5 l=0
modp_28 ni_3_2_3 n_3_4 m_5 debug coeff1=0.001 act_l=0.0002
splitter1to2_30 n_2_3 ni_3_3_1 ni_3_3_2
wg_31 ni_3_3_1 ni_3_3_3 l=0
wg_32 ni_3_3_2 n_3_7 l=0
modp_33 ni_3_3_3 n_3_6 m_6 debug coeff1=0.001 act_l=0.0002
splitter1to2_35 n_3_0 ni_4_0_1 ni_4_0_2
wg_36 ni_4_0_1 ni_4_0_3 l=0
wg_37 ni_4_0_2 n_4_1 l=0
modp_38 ni_4_0_3 n_4_0 m_7 debug coeff1=0.001 act_l=0.0002
splitter1to2_40 n_3_1 ni_4_1_1 ni_4_1_2
wg_41 ni_4_1_1 ni_4_1_3 l=0
wg_42 ni_4_1_2 n_4_3 l=0
modp_43 ni_4_1_3 n_4_2 m_8 debug coeff1=0.001 act_l=0.0002
splitter1to2_45 n_3_2 ni_4_2_1 ni_4_2_2
wg_46 ni_4_2_1 ni_4_2_3 l=0
wg_47 ni_4_2_2 n_4_5 l=0
modp_48 ni_4_2_3 n_4_4 m_9 debug coeff1=0.001 act_l=0.0002
splitter1to2_50 n_3_3 ni_4_3_1 ni_4_3_2
wg_51 ni_4_3_1 ni_4_3_3 l=0
wg_52 ni_4_3_2 n_4_7 l=0
modp_53 ni_4_3_3 n_4_6 m_10 debug coeff1=0.001 act_l=0.0002
splitter1to2_55 n_3_4 ni_4_4_1 ni_4_4_2
wg_56 ni_4_4_1 ni_4_4_3 l=0
wg_57 ni_4_4_2 n_4_9 l=0
modp_58 ni_4_4_3 n_4_8 m_11 debug coeff1=0.001 act_l=0.0002
splitter1to2_60 n_3_5 ni_4_5_1 ni_4_5_2
wg_61 ni_4_5_1 ni_4_5_3 l=0
wg_62 ni_4_5_2 n_4_11 l=0
modp_63 ni_4_5_3 n_4_10 m_12 debug coeff1=0.001 act_l=0.0002
splitter1to2_65 n_3_6 ni_4_6_1 ni_4_6_2
wg_66 ni_4_6_1 ni_4_6_3 l=0
wg_67 ni_4_6_2 n_4_13 l=0
modp_68 ni_4_6_3 n_4_12 m_13 debug coeff1=0.001 act_l=0.0002
splitter1to2_70 n_3_7 ni_4_7_1 ni_4_7_2
wg_71 ni_4_7_1 ni_4_7_3 l=0
wg_72 ni_4_7_2 n_4_15 l=0
modp_73 ni_4_7_3 n_4_14 m_14 debug coeff1=0.001 act_l=0.0002
.mode neff=2.35 ng=2.35 wl=1.5525243811496633e-06
.freq 193.1thz 193.4thz 1
.source 1.0@n_0_0 power=0.005w eff=0.2
.prob n_4_0 n_4_1 n_4_2 n_4_3 n_4_4 n_4_5 n_4_6 n_4_7 n_4_8 n_4_9 n_4_10 n_4_11 n_4_12 n_4_13 n_4_14 n_4_15
